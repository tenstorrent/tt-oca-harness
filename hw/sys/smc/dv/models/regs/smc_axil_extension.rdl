// SPDX-License-Identifier: Apache-2.0
// SPDX-FileCopyrightText: 2026 Tenstorrent USA, Inc.

`ifndef SMC_AXIL_EXTENSION_RDL
`define SMC_AXIL_EXTENSION_RDL

// OCAH: AXIL extension region. This is the designated adopter/extension window:
// open-source builds reserve the region only, while an overlay can override
// this file to instantiate external peripherals plus their own sub-block RDLs.
// A uniquely named footprint mem
// keeps the generated C type distinct from the other placeholder wrappers and
// reserves the full 6 x 0x400 window addressed by smc_top @ +0x040_0000.
mem smc_axil_extension_placeholder_mem #(
    longint unsigned NUM_ENTRIES = 1536,
    longint unsigned WIDTH       = 32
) {
    desc = "Placeholder footprint (AXIL extension region; peripherals provided by overlay)";

    mementries = NUM_ENTRIES;
    memwidth   = WIDTH;

    reg mem_word {
        regwidth = 32;
        field { sw = r; hw = r; } data[WIDTH-1:0];
    };

    mem_word mem_array[NUM_ENTRIES];
};

addrmap smc_axil_extension {
    external smc_axil_extension_placeholder_mem footprint @0x0;
};

`endif
