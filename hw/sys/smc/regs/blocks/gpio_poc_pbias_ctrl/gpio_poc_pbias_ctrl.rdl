// SPDX-License-Identifier: Apache-2.0
// SPDX-FileCopyrightText: 2026 Tenstorrent USA, Inc.

`ifndef GPIO_POC_PBIAS_CTRL_RDL_DEFINED
`define GPIO_POC_PBIAS_CTRL_RDL_DEFINED

addrmap gpio_poc_pbias_ctrl {
    name = "GPIO POC and PBIAS Control Address Map";
    desc = "GPIO POC and PBIAS Control Register Interface";

    
    ////////////////////////////////////////////////////////////////////////////
    // Register Definitions
    ////////////////////////////////////////////////////////////////////////////
    //---------------------------------

    reg CONTROL {
        regwidth = 32;
        accesswidth = 32;

        field {
            sw = rw;
            hw = r;
            desc = "Power supply voltage level selection.
                    PSW=0 at 1.8V I/O supply
                    PSW=1 at 1.2V I/O supply";
        } pwr_supply_sel[0:0] = 0x0;

        field {
            sw = rw;
            hw = r;
            desc = "Retention enable control. Set to 0 by default which disables retention.";
        } retention_en[1:1] = 0x0;
    };

    reg ACCESS_FILTER {
        field {
            sw = rw;
            hw = r;
            desc = "Filter Enable - when set, only SEP may access the GPIO register interface. This effectivley makes the GPIO a SEP-only interface.";
        } write_filter_enable[0:0] = 0x0;

        field {
            sw = rw;
            hw = r;
            desc = "Filter Value - the value that must be written to the filter register to allow access to the GPIO register interface.";
        } read_filter_enable[1:1] = 0x0;

        field {
            sw = rw;
            hw = r;
            desc = "When write_filter_enable is set, only allow write accesses with this prot value";
        } awprot_requirement[10:8] = 0x1;

        field {
            sw = rw;
            hw = r;
            desc = "When read_filter_enable is set, only allow read accesses with this prot value";
        } arprot_requirement[18:16] = 0x1;
    };


    ////////////////////////////////////////////////////////////////////////////
    // Address Map
    ////////////////////////////////////////////////////////////////////////////

    external CONTROL    CONTROL         @0x0;
    ACCESS_FILTER       ACCESS_FILTER   @0x8;
};

`endif
