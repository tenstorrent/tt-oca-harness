// SPDX-License-Identifier: Apache-2.0
// SPDX-FileCopyrightText: 2026 Tenstorrent USA, Inc.

`ifndef DEBUG_MODULE_REG_RDL
`define DEBUG_MODULE_REG_RDL

addrmap debug_module {
    name = "Debug Module Hart Interface";
    desc = "Memory region through which a hart in Debug Mode exchanges state with the Debug Module: handshake mailboxes, generated instructions, program buffer, data registers, per-hart flags and the debug ROM. The debugger-facing Debug Module registers (dmcontrol, dmstatus, abstractcs, sbcs, ...) are reached over the Debug Module Interface and do not appear in this map.";

    ////////////////////////////////////////////////////////////////////////////
    // Register Definitions
    ////////////////////////////////////////////////////////////////////////////

    reg HALTED {
        field {
            sw = w;
            hw = r;
            desc = "Debug ROM causes the hart to write its hart ID here when it is in Debug Mode.";
        } hartid [9:0];
    };

    reg GOING {
        field {
            sw = w;
            hw = r;
            desc = "Debug ROM causes the hart to write 0 here when it begins executing Debug Mode instructions.";
        } hartid [9:0];
    };

    reg RESUMING {
        field {
            sw = w;
            hw = r;
            desc = "Debug ROM causes the hart to write its hart ID here when it leaves Debug Mode.";
        } hartid [9:0];
    };

    reg EXCEPTION {
        field {
            sw = w;
            hw = r;
            desc = "Debug ROM causes the hart to write 0 here if it takes an exception in Debug Mode.";
        } hartid [9:0];
    };

    reg WHERETO {
        field {
            sw = r;
            hw = w;
            desc = "Jump instruction filled in by the Debug Module to direct the hart in Debug Mode.";
        } instr [31:0];
    };

    reg ABSTRACT {
        field {
            sw = r;
            hw = w;
            desc = "Instruction generated by the Debug Module for the current abstract command.";
        } instr [31:0];
    };

    reg PROGBUF {
        field {
            sw = rw;
            hw = r;
            desc = "Program buffer word shared with the debugger. Byte accesses are supported.";
        } data [31:0] = 0x0;
    };

    reg IMPEBREAK {
        field {
            sw = r;
            hw = r;
            desc = "Implicit EBREAK instruction following the program buffer.";
        } instr [31:0] = 0x0010_0073;
    };

    reg DATA {
        field {
            sw = rw;
            hw = r;
            desc = "Abstract command data word shared with the debugger. Byte accesses are supported.";
        } data [31:0] = 0x0;
    };

    reg FLAGS {
        desc = "One flag byte per hart, at byte offset equal to the hart ID. Bit 0 is go (execute the command at WHERETO); bit 1 is resume (leave Debug Mode). Bits 7:2 read as 0.";
        field { sw = r; hw = w; desc = "Hart 0 go/resume flags."; } flags_0 [7:0];
        field { sw = r; hw = w; desc = "Hart 1 go/resume flags."; } flags_1 [15:8];
        field { sw = r; hw = w; desc = "Hart 2 go/resume flags."; } flags_2 [23:16];
        field { sw = r; hw = w; desc = "Hart 3 go/resume flags."; } flags_3 [31:24];
    };

    reg ROM {
        field {
            sw = r;
            hw = r;
            desc = "Debug ROM word. Holds the fixed Debug Mode entry, exception and resume handlers.";
        } data [31:0];
    };

    ////////////////////////////////////////////////////////////////////////////
    // Address Map
    ////////////////////////////////////////////////////////////////////////////

    HALTED      HALTED      @0x100;
    GOING       GOING       @0x104;
    RESUMING    RESUMING    @0x108;
    EXCEPTION   EXCEPTION   @0x10C;
    WHERETO     WHERETO     @0x300;
    ABSTRACT    ABSTRACT[5] @0x328;
    PROGBUF     PROGBUF[16] @0x33C;
    IMPEBREAK   IMPEBREAK   @0x37C;
    DATA        DATA[4]     @0x380;
    FLAGS       FLAGS       @0x400;
    ROM         ROM[26]     @0x800;
};

`endif
