// SPDX-License-Identifier: Apache-2.0
// SPDX-FileCopyrightText: 2026 Tenstorrent USA, Inc.

`ifndef DEBUG_MODULE_REG_RDL
`define DEBUG_MODULE_REG_RDL

addrmap debug_module {
    name = "RISC-V Debug Module Registers";
    desc = "RISC-V External Debug Support Version 0.13.2 - Section 3.12. Field reset values updated as per specification and user rules (Preset/- -> 0x0). HW access permissions are derived based on SW access. SW 'w' access changed to 'rw'. Fields previously rw1c now use 'woclr'.";

    // Type definition for Abstract Data Registers
    reg abstractdata {
        desc = "Abstract Data Register. Used for arguments/return values of abstract commands.";
        field {
            sw = rw;
            hw = r;
            desc = "Data value for abstract commands.";
        } data [31:0] = 0x0;
    };

    // Section 3.12.2 Debug Module Control (dmcontrol)
    reg dmcontrol {
        name = "Debug Module Control";
        desc = "Controls the overall Debug Module and selected harts. Writes to action bits (haltreq, resumereq, etc.) apply to the new value of hartsel and hasel.";
        field {
            sw = rw;
            hw = r;
            desc = "Halt request for currently selected harts. Write 0 to clear, 1 to set.";
        } haltreq [31:31] = 0x0;
        field {
            sw = rw;
            hw = r;
            onwrite = woset; // W1 field
            desc = "Resume request for currently selected harts. Writing 1 causes halted harts to resume and clears their resume ack bit. Ignored if haltreq is set.";
        } resumereq [30:30] = 0x0;
        field {
            sw = rw;
            hw = r;
            desc = "Optional. Hart reset for currently selected harts. Write 1, then 0 to deassert. Debugger must not change selection while this is 1. If not implemented, reads as 0.";
        } hartreset [29:29] = 0x0;
        field {
            sw = rw;
            hw = r;
            onwrite = woset; // W1 field
            desc = "Writing 1 clears havereset for any selected harts.";
        } ackhavereset [28:28] = 0x0;
        field {
            sw = r;
            hw = w;
            desc = "Reserved.";
        } _reserved_27 [27:27] = 0x0;
        field {
            sw = rw;
            hw = r;
            desc = "Selects definition of currently selected harts. 0: single hart by hartsel. 1: hart by hartsel plus those by hart array mask. Tied to 0 if hart array mask not implemented.";
        } hasel [26:26] = 0x0;
        field {
            sw = rw;
            hw = r;
            desc = "Low 10 bits of hartsel: DM-specific index of the hart to select.";
        } hartsello [25:16] = 0x0;
        field {
            sw = rw;
            hw = r;
            desc = "High 10 bits of hartsel: DM-specific index of the hart to select.";
        } hartselhi [15:6] = 0x0;
        field {
            sw = r;
            hw = w;
            desc = "Reserved.";
        } _reserved_5_4 [5:4] = 0x0;
        field {
            sw = rw;
            hw = r;
            onwrite = woset; // W1 field
            desc = "Optional (if dmstatus.hasresethaltreq=1). Writing 1 sets halt-on-reset request bit for selected harts (unless clrresethaltreq is also 1).";
        } setresethaltreq [3:3] = 0x0;
        field {
            sw = rw;
            hw = r;
            onwrite = woset; // W1 field
            desc = "Optional (if dmstatus.hasresethaltreq=1). Writing 1 clears halt-on-reset request bit for selected harts.";
        } clrresethaltreq [2:2] = 0x0;
        field {
            sw = rw;
            hw = r;
            desc = "Controls reset signal from DM to system (ndmreset). Write 1, then 0 to deassert.";
        } ndmreset [1:1] = 0x0;
        field {
            sw = rw;
            hw = r;
            desc = "Debug Module active and reset. 0: DM takes reset values (except this bit). 1: DM functions normally.";
        } dmactive [0:0] = 0x0;
    };

    // Section 3.12.1 Debug Module Status (dmstatus)
    reg dmstatus {
        name = "Debug Module Status";
        desc = "Reports status for the Debug Module and currently selected harts. This entire register is read-only.";
        field { sw = r; hw = w; desc = "Reserved."; } _reserved_31_23 [31:23] = 0x0;
        field { sw = r; hw = w; desc = "1: Implicit ebreak after Program Buffer. Must be 1 if abstractcs.progbufsize is 1."; } impebreak [22:22] = 0x0;
        field { sw = r; hw = w; desc = "Reserved."; } _reserved_21_20 [21:20] = 0x0;
        field { sw = r; hw = w; desc = "1: All currently selected harts have been reset and not acknowledged."; } allhavereset [19:19] = 0x0;
        field { sw = r; hw = w; desc = "1: At least one currently selected hart has been reset and not acknowledged."; } anyhavereset [18:18] = 0x0;
        field { sw = r; hw = w; desc = "1: All currently selected harts have acknowledged their last resume request."; } allresumeack [17:17] = 0x0;
        field { sw = r; hw = w; desc = "1: Any currently selected hart has acknowledged its last resume request."; } anyresumeack [16:16] = 0x0;
        field { sw = r; hw = w; desc = "1: All currently selected harts do not exist in this platform."; } allnonexistent [15:15] = 0x0;
        field { sw = r; hw = w; desc = "1: Any currently selected hart does not exist in this platform."; } anynonexistent [14:14] = 0x0;
        field { sw = r; hw = w; desc = "1: All currently selected harts are unavailable."; } allunavail [13:13] = 0x0;
        field { sw = r; hw = w; desc = "1: Any currently selected hart is unavailable."; } anyunavail [12:12] = 0x0;
        field { sw = r; hw = w; desc = "1: All currently selected harts are running."; } allrunning [11:11] = 0x0;
        field { sw = r; hw = w; desc = "1: Any currently selected hart is running."; } anyrunning [10:10] = 0x0;
        field { sw = r; hw = w; desc = "1: All currently selected harts are halted."; } allhalted [9:9] = 0x0;
        field { sw = r; hw = w; desc = "1: Any currently selected hart is halted."; } anyhalted [8:8] = 0x0;
        field { sw = r; hw = w; desc = "0: Authentication required. 1: Authentication passed. Preset to 1 if no authentication implemented."; } authenticated [7:7] = 0x0;
        field { sw = r; hw = w; desc = "0: Authentication module ready. 1: Authentication module busy."; } authbusy [6:6] = 0x0;
        field { sw = r; hw = w; desc = "1: DM supports halt-on-reset functionality (setresethaltreq/clrresethaltreq bits in dmcontrol)."; } hasresethaltreq [5:5] = 0x0;
        field { sw = r; hw = w; desc = "0: confstrptr0-3 are not relevant to config string. 1: confstrptr0-3 hold config string address."; } confstrptrvalid [4:4] = 0x0;
        field {
            sw = r;
            hw = w;
            desc = "Debug Module version. 0=No DM, 1=v0.11, 2=v0.13, 15=Non-conformant.";
        } version [3:0] = 0x2;
    };

    // Section 3.12.3 Hart Info (hartinfo)
    reg hartinfo {
        name = "Hart Info";
        desc = "Information about the hart currently selected by hartsel. Optional; reads all-zero if not present. Entire register is read-only.";
        field { sw = r; hw = w; desc = "Reserved."; } _reserved_31_24 [31:24] = 0x0;
        field { sw = r; hw = w; desc = "Number of dscratch registers available for debugger use during program buffer execution (dscratch0 upwards)."; } nscratch [23:20] = 0x0;
        field { sw = r; hw = w; desc = "Reserved."; } _reserved_19_17 [19:17] = 0x0;
        field { sw = r; hw = w; desc = "0: Data registers (dataN) are shadowed by CSRs. 1: Data registers are shadowed in hart's memory map."; } dataaccess [16:16] = 0x0;
        field { sw = r; hw = w; desc = "If dataaccess=0: Number of CSRs for dataN. If dataaccess=1: Number of 32-bit words in memory map for dataN. Max value 12."; } datasize [15:12] = 0x0;
        field { sw = r; hw = w; desc = "If dataaccess=0: Number of first CSR for dataN. If dataaccess=1: Signed address of RAM where dataN are shadowed (relative to zero)."; } dataaddr [11:0] = 0x0;
    };

    // Section 3.12.15 Halt Summary 1 (haltsum1)
    reg haltsum1 {
        name = "Halt Summary 1";
        desc = "Read-only. Each bit indicates if any hart in a group of 32 is halted. May not be present in systems with fewer than 33 harts. Unavailable/nonexistent harts are not considered halted.";
        field {
            sw = r;
            hw = w;
            desc = "Halt status summary. LSB for harts {hartsel[19:10],10'h0}-{hartsel[19:10],10'h1f}, MSB for harts {hartsel[19:10],10'h3e0}-{hartsel[19:10],10'h3ff}.";
        } haltsum1 [31:0] = 0x0;
    };

    // Section 3.12.4 Hart Array Window Select (hawindowsel)
    reg hawindowsel {
        name = "Hart Array Window Select";
        desc = "Selects which 32-bit portion of the hart array mask register is accessible in hawindow.";
        field { sw = r; hw = w; desc = "Reserved. High bits may be tied to 0 depending on hart array mask size."; } _reserved_31_15 [31:15] = 0x0;
        field {
            sw = rw;
            hw = r;
            desc = "Window select for hart array mask register. E.g., on a system with 48 harts, only bit 0 may be writable.";
        } hawindowsel [14:0] = 0x0;
    };

    // Section 3.12.5 Hart Array Window (hawindow)
    reg hawindow {
        name = "Hart Array Window";
        desc = "R/W access to a 32-bit portion of the hart array mask register, selected by hawindowsel.";
        field {
            sw = rw;
            hw = r;
            desc = "32-bit window into the hart array mask register. Some bits may be constant 0, depending on hawindowsel and implemented harts.";
        } maskdata [31:0] = 0x0;
    };

    // Section 3.12.6 Abstract Control and Status (abstractcs)
    reg abstractcs {
        name = "Abstract Control and Status";
        desc = "Controls and status for abstract commands. Writing this register while an abstract command is executing (busy=1) sets cmderr to 1 (busy) if cmderr was 0.";
        field { sw = r; hw = w; desc = "Reserved."; } _reserved_31_29 [31:29] = 0x0;
        field { sw = r; hw = w; desc = "Size of the Program Buffer, in 32-bit words. Valid sizes are 0-16."; } progbufsize [28:24] = 0x0;
        field { sw = r; hw = w; desc = "Reserved."; } _reserved_23_13 [23:13] = 0x0;
        field { sw = r; hw = w; desc = "1: An abstract command is currently being executed. Set when 'command' is written, cleared on completion."; } busy [12:12] = 0x0;
        field { sw = r; hw = w; desc = "Reserved."; } _reserved_11 [11:11] = 0x0;
        field {
            sw = rw;
            hw = r;
            woclr;
            desc = "Abstract command error status. Remains set until cleared. Valid if busy=0. 0=none, 1=busy, 2=not_supported, 3=exception, 4=halt/resume, 5=bus, 7=other.";
        } cmderr [10:8] = 0x0;
        field { sw = r; hw = w; desc = "Reserved."; } _reserved_7_4 [7:4] = 0x0;
        field { sw = r; hw = w; desc = "Number of data registers (dataN) implemented. Valid sizes are 1-12."; } datacount [3:0] = 0x0;
    };

    // Section 3.12.7 Abstract Command (command)
    reg command {
        name = "Abstract Command";
        desc = "Writes cause corresponding abstract command to execute. Writing while busy sets cmderr=1 (if cmderr=0). Ignored if cmderr is non-zero.";
        field {
            sw = rw;
            hw = r;
            desc = "Type of abstract command (e.g., 0 for Access Register, 1 for Quick Access, 2 for Access Memory).";
        } cmdtype [31:24] = 0x0;
        field {
            sw = rw;
            hw = r;
            desc = "Command-specific control field.";
        } control [23:0] = 0x0;
    };

    // Section 3.12.8 Abstract Command Autoexec (abstractauto)
    reg abstractauto {
        name = "Abstract Command Autoexec";
        desc = "Optional. Allows more efficient burst accesses. Writing while busy sets cmderr=1 (if cmderr=0). Detect support by R/W test.";
        field {
            sw = rw;
            hw = r;
            desc = "Bitmask (16 bits). If bit N=1, R/W to progbufN re-executes command in 'command' register.";
        } autoexecprogbuf [31:16] = 0x0;
        field { sw = r; hw = w; desc = "Reserved."; } _reserved_15_12 [15:12] = 0x0;
        field {
            sw = rw;
            hw = r;
            desc = "Bitmask (12 bits). If bit N=1, R/W to dataN re-executes command in 'command' register.";
        } autoexecdata [11:0] = 0x0;
    };

    // Type definition for Configuration String Pointer Registers
    reg confstrptr {
        desc = "Part of configuration string pointer address (if dmstatus.confstrptrvalid=1) or unspecified identifier information. Read-only.";
        field {
            sw = r;
            hw = w;
            desc = "Bits of configuration string pointer or identifier information.";
        } addr [31:0] = 0x0;
    };

    // Section 3.12.10 Next Debug Module (nextdm)
    reg nextdm {
        name = "Next Debug Module";
        desc = "If multiple DMs on DMI, this holds base address of the next DM. 0 if this is the last. Read-only.";
        field {
            sw = r;
            hw = w;
            desc = "Base address of the next Debug Module or 0.";
        } addr [31:0] = 0x0;
    };

    // Type definition for Program Buffer Registers
    reg progbuf {
        desc = "Program Buffer word. For debugger to write small programs.";
        field {
            sw = rw;
            hw = r;
            desc = "Program instruction word.";
        } data [31:0] = 0x0;
    };


    // Section 3.12.13 Authentication Data (authdata)
    reg authdata {
        name = "Authentication Data";
        desc = "32-bit serial port to/from authentication module. Use when dmstatus.authbusy is clear.";
        field {
            sw = rw;
            hw = r;
            desc = "Data for authentication mechanism.";
        } data [31:0] = 0x0;
    };

    // Section 3.12.16 Halt Summary 2 (haltsum2)
    reg haltsum2 {
        name = "Halt Summary 2";
        desc = "Read-only. Each bit indicates if any hart in a group of 1024 is halted. May not be present if < 1025 harts.";
        field {
            sw = r;
            hw = w;
            desc = "Halt status summary. LSB for harts {hartsel[19:15],15'h0}-{hartsel[19:15],15'h3ff}, etc.";
        } haltsum2 [31:0] = 0x0;
    };

    // Section 3.12.17 Halt Summary 3 (haltsum3)
    reg haltsum3 {
        name = "Halt Summary 3";
        desc = "Read-only. Each bit indicates if any hart in a group of 32768 is halted. May not be present if < 32769 harts.";
        field {
            sw = r;
            hw = w;
            desc = "Halt status summary. LSB for harts 20'h0-20'h7fff, etc.";
        } haltsum3 [31:0] = 0x0;
    };

    // Section 3.12.22 System Bus Address 127:96 (sbaddress3)
    reg sbaddress3 {
        name = "System Bus Address 127:96";
        desc = "Bits 127:96 of the physical system bus address for System Bus Access. Not present if sbcs.sbasize < 97. Writes while sbcs.sbbusy=1 set sbcs.sbbusyerror.";
        field {
            sw = rw;
            hw = r;
            desc = "Address bits 127:96 for system bus access.";
        } address [31:0] = 0x0;
    };

    // Section 3.12.18 System Bus Access Control and Status (sbcs)
    reg sbcs {
        name = "System Bus Access Control and Status";
        desc = "Controls and status for the System Bus Access master. Writes while sbbusy=1 result in undefined behavior.";
        field { sw = r; hw = w; desc = "System Bus interface version. 0=pre-2018 drafts, 1=this version (0.13)."; } sbversion [31:29] = 0x1;
        field { sw = r; hw = w; desc = "Reserved."; } _reserved_28_23 [28:23] = 0x0;
        field {
            sw = rw;
            hw = r;
            woclr;
            desc = "System bus busy error. Set if access attempted while busy or read while read in progress. No new access if set.";
        } sbbusyerror [22:22] = 0x0;
        field { sw = r; hw = w; desc = "1: System bus master is busy. Goes high on access request, low on completion."; } sbbusy [21:21] = 0x0;
        field { sw = rw; hw = r; desc = "1: Every write to sbaddress0 automatically triggers a system bus read at the new address."; } sbreadonaddr [20:20] = 0x0;
        field { sw = rw; hw = r; desc = "Access size for system bus accesses: 0=8-bit, 1=16-bit, 2=32-bit, 3=64-bit, 4=128-bit. If unsupported, access fails, sberror=4."; } sbaccess [19:17] = 0x2;
        field { sw = rw; hw = r; desc = "1: sbaddress is incremented by access size (from sbaccess) after every system bus access."; } sbautoincrement [16:16] = 0x0;
        field { sw = rw; hw = r; desc = "1: Every read from sbdata0 automatically triggers a system bus read at (possibly auto-incremented) address."; } sbreadondata [15:15] = 0x0;
        field {
            sw = rw;
            hw = r;
            woclr;
            desc = "System bus master error flags. No new access if non-zero. 0=none, 1=timeout, 2=bad_address, 3=alignment, 4=unsupported_size, 7=other.";
        } sberror [14:12] = 0x0;
        field {
            sw = r;
            hw = w;
            desc = "Width of system bus addresses in bits. The integrated debug module reports 56. Zero indicates no system bus access support.";
        } sbasize [11:5] = 0x38;
        field { sw = r; hw = w; desc = "1: 128-bit system bus accesses are supported."; } sbaccess128 [4:4] = 0x0;
        field { sw = r; hw = w; desc = "1: 64-bit system bus accesses are supported."; } sbaccess64 [3:3] = 0x1;
        field { sw = r; hw = w; desc = "1: 32-bit system bus accesses are supported."; } sbaccess32 [2:2] = 0x1;
        field { sw = r; hw = w; desc = "1: 16-bit system bus accesses are supported."; } sbaccess16 [1:1] = 0x1;
        field { sw = r; hw = w; desc = "1: 8-bit system bus accesses are supported."; } sbaccess8 [0:0] = 0x1;
    };

    // Section 3.12.19 System Bus Address 31:0 (sbaddress0)
    reg sbaddress0 {
        name = "System Bus Address 31:0";
        desc = "Bits 31:0 of the physical system bus address. Not present if sbcs.sbasize=0. Writes while sbcs.sbbusy=1 set sbcs.sbbusyerror. If sbcs.sberror=0, sbcs.sbbusyerror=0, and sbcs.sbreadonaddr=1, write triggers read sequence.";
        field {
            sw = rw;
            hw = r;
            desc = "Address bits 31:0.";
        } address [31:0] = 0x0;
    };

    // Section 3.12.20 System Bus Address 63:32 (sbaddress1)
    reg sbaddress1 {
        name = "System Bus Address 63:32";
        desc = "Bits 63:32 of the physical system bus address. Not present if sbcs.sbasize < 33. Writes while sbcs.sbbusy=1 set sbcs.sbbusyerror.";
        field {
            sw = rw;
            hw = r;
            desc = "Address bits 63:32.";
        } address [31:0] = 0x0;
    };

    // Section 3.12.21 System Bus Address 95:64 (sbaddress2)
    reg sbaddress2 {
        name = "System Bus Address 95:64";
        desc = "Bits 95:64 of the physical system bus address. Not present if sbcs.sbasize < 65. Writes while sbcs.sbbusy=1 set sbcs.sbbusyerror.";
        field {
            sw = rw;
            hw = r;
            desc = "Address bits 95:64.";
        } address [31:0] = 0x0;
    };

    // Section 3.12.23 System Bus Data 31:0 (sbdata0)
    reg sbdata0 {
        name = "System Bus Data 31:0";
        desc = "Bits 31:0 of system bus data. Not present if all sbcs.sbaccess* flags are 0. Accesses do nothing if sbcs.sberror or sbcs.sbbusyerror are non-zero. Accesses while sbcs.sbbusy=1 set sbcs.sbbusyerror. Write triggers bus write sequence. Read triggers read sequence including conditional next read if sbcs.sbreadondata=1.";
        field {
            sw = rw;
            hw = r;
            desc = "Data bits 31:0.";
        } data [31:0] = 0x0;
    };

    // Section 3.12.24 System Bus Data 63:32 (sbdata1)
    reg sbdata1 {
        name = "System Bus Data 63:32";
        desc = "Bits 63:32 of system bus data. Not present if sbcs.sbaccess64 and sbcs.sbaccess128 are 0. Accesses while sbcs.sbbusy=1 set sbcs.sbbusyerror.";
        field {
            sw = rw;
            hw = r;
            desc = "Data bits 63:32.";
        } data [31:0] = 0x0;
    };

    // Section 3.12.25 System Bus Data 95:64 (sbdata2)
    reg sbdata2 {
        name = "System Bus Data 95:64";
        desc = "Bits 95:64 of system bus data. Only exists if sbcs.sbaccess128=1. Accesses while sbcs.sbbusy=1 set sbcs.sbbusyerror.";
        field {
            sw = rw;
            hw = r;
            desc = "Data bits 95:64.";
        } data [31:0] = 0x0;
    };

    // Section 3.12.26 System Bus Data 127:96 (sbdata3)
    reg sbdata3 {
        name = "System Bus Data 127:96";
        desc = "Bits 127:96 of system bus data. Only exists if sbcs.sbaccess128=1. Accesses while sbcs.sbbusy=1 set sbcs.sbbusyerror.";
        field {
            sw = rw;
            hw = r;
            desc = "Data bits 127:96.";
        } data [31:0] = 0x0;
    };

    // Section 3.12.14 Halt Summary 0 (haltsum0)
    reg haltsum0 {
        name = "Halt Summary 0";
        desc = "Read-only. Each bit indicates whether one specific hart is halted. Unavailable/nonexistent harts are not considered halted. LSB for hart {hartsel[19:5],5'h0}, MSB for hart {hartsel[19:5],5'h1f}.";
        field {
            sw = r;
            hw = w;
            desc = "Halt status for 32 harts based on hartsel[19:5].";
        } haltsum0 [31:0] = 0x0;
    };

    // Assembled Address Map
    // REGISTER_NAME             INSTANCE_NAME                   ADDRESS
    //--------------------------------------------------------------------
    abstractdata                abstractdata[12]                @0x10;
    dmcontrol                   dmcontrol                       @0x40;
    dmstatus                    dmstatus                        @0x44;
    hartinfo                    hartinfo                        @0x48;
    haltsum1                    haltsum1                        @0x4C;
    hawindowsel                 hawindowsel                     @0x50;
    hawindow                    hawindow                        @0x54;
    abstractcs                  abstractcs                      @0x58;
    command                     command                         @0x5C;
    abstractauto                abstractauto                    @0x60;
    confstrptr                  confstrptr[3]                   @0x64;
    nextdm                      nextdm                          @0x74;
    progbuf                     progbuf[16]                     @0x80;
    authdata                    authdata                        @0xC0;
    haltsum2                    haltsum2                        @0xD0;
    haltsum3                    haltsum3                        @0xD4;
    sbaddress3                  sbaddress3                      @0xDC;
    sbcs                        sbcs                            @0xE0;
    sbaddress0                  sbaddress0                      @0xE4;
    sbaddress1                  sbaddress1                      @0xE8;
    sbaddress2                  sbaddress2                      @0xEC;
    sbdata0                     sbdata0                         @0xF0;
    sbdata1                     sbdata1                         @0xF4;
    sbdata2                     sbdata2                         @0xF8;
    sbdata3                     sbdata3                         @0xFC;
    haltsum0                    haltsum0                        @0x100;
};

`endif
