// SPDX-License-Identifier: Apache-2.0
// SPDX-FileCopyrightText: 2026 Tenstorrent USA, Inc.

`ifndef SMC_EFUSE_MAP_RDL_DEFINED
`define SMC_EFUSE_MAP_RDL_DEFINED

addrmap smc_efuse_map {

    name = "Efuse address map of physical efuse macro";
    desc = "Address map for efuse shadow registers providing access to various chip configuration and ID fields";

    //////////////////////////
    // Register Definitions //
    //////////////////////////

    default regwidth = 64;
    default accesswidth = 64;

    // The map fills exactly one 2048-bit efuse bank and must tile it without gaps: the
    // efuse_map_t union in smc_efuse_pkg overlays a field struct on the raw word array, and an
    // unmapped address resolves to the lock meta-field sentinel, which is never lock-checked and
    // would leave programmable OTP that cannot be locked.
    //
    // HARNESS_LOCKS and SUPPLEMENTARY_LOCKS are hardware-consumed lock meta-fields and sit together at
    // the top of the map. HARNESS_LOCKS holds one write/read pair per lockable field, at bits 2n
    // and 2n+1 of slot n. Slots 0-3 go to the functional registers, slots 4-6 to SPARE[0] through
    // SPARE[2] and slot 7 to SPARE_TAIL; slots 8-31 are reserved. The 64-bit field addresses at
    // most 32 slots, since the hardware indexes this register directly.
    reg HARNESS_LOCKS {
        desc = "Lock controls for each fuse field. When write locked, the corresponding field is not
                programmable. When read locked, the shadow register is not readable.

                A write to the shadow register of a write-locked field, or a read of the shadow
                register of a read-locked field, completes with SLVERR and read data 0xBADCAB1E,
                leaves the shadow register unchanged and raises the locked-field access interrupt
                for the duration of the access. An attempted fuse program of a write-locked field,
                or an attempted fuse read of a read-locked field, started through the eFuse
                interface control registers is refused and sets
                EFUSE_INTERFACE_CTRL_STATUS.efuse_req_error until it is cleared.";

        field {
            sw = rw;
            onwrite = woset;
            hw = r;
            desc = "JTAG public identity write lock (slot 0). When set, JTAG_PUBLIC_IDENTITY is not writable.";
        } jtag_public_identity_write_lock[0:0] = 0x0;

        field {
            sw = rw;
            onwrite = woset;
            hw = r;
            desc = "JTAG public identity read lock (slot 0). When set, JTAG_PUBLIC_IDENTITY is not readable.";
        } jtag_public_identity_read_lock[1:1] = 0x0;

        field {
            sw = rw;
            onwrite = woset;
            hw = r;
            desc = "I2C/I3C ID write lock (slot 1). When set, no I2C_I3C_ID element is writable.";
        } i2c_i3c_id_write_lock[2:2] = 0x0;

        field {
            sw = rw;
            onwrite = woset;
            hw = r;
            desc = "I2C/I3C ID read lock (slot 1). When set, no I2C_I3C_ID element is readable.";
        } i2c_i3c_id_read_lock[3:3] = 0x0;

        field {
            sw = rw;
            onwrite = woset;
            hw = r;
            desc = "SMC config write lock (slot 2). When set, SMC_CONFIG is not writable.";
        } smc_config_write_lock[4:4] = 0x0;

        field {
            sw = rw;
            onwrite = woset;
            hw = r;
            desc = "SMC config read lock (slot 2). When set, SMC_CONFIG is not readable.";
        } smc_config_read_lock[5:5] = 0x0;

        field {
            sw = rw;
            onwrite = woset;
            hw = r;
            desc = "OCCP transport timeout write lock (slot 3). When set, OCCP_TRANSPORT_TIMEOUT is not writable.";
        } occp_transport_timeout_write_lock[6:6] = 0x0;

        field {
            sw = rw;
            onwrite = woset;
            hw = r;
            desc = "OCCP transport timeout read lock (slot 3). When set, OCCP_TRANSPORT_TIMEOUT is not readable.";
        } occp_transport_timeout_read_lock[7:7] = 0x0;

        field {
            sw = rw;
            onwrite = woset;
            hw = r;
            desc = "Spare 0 write lock (slot 4). When set, SPARE[0] is not writable.";
        } spare0_write_lock[8:8] = 0x0;

        field {
            sw = rw;
            onwrite = woset;
            hw = r;
            desc = "Spare 0 read lock (slot 4). When set, SPARE[0] is not readable.";
        } spare0_read_lock[9:9] = 0x0;

        field {
            sw = rw;
            onwrite = woset;
            hw = r;
            desc = "Spare 1 write lock (slot 5). When set, SPARE[1] is not writable.";
        } spare1_write_lock[10:10] = 0x0;

        field {
            sw = rw;
            onwrite = woset;
            hw = r;
            desc = "Spare 1 read lock (slot 5). When set, SPARE[1] is not readable.";
        } spare1_read_lock[11:11] = 0x0;

        field {
            sw = rw;
            onwrite = woset;
            hw = r;
            desc = "Spare 2 write lock (slot 6). When set, SPARE[2] is not writable.";
        } spare2_write_lock[12:12] = 0x0;

        field {
            sw = rw;
            onwrite = woset;
            hw = r;
            desc = "Spare 2 read lock (slot 6). When set, SPARE[2] is not readable.";
        } spare2_read_lock[13:13] = 0x0;

        field {
            sw = rw;
            onwrite = woset;
            hw = r;
            desc = "Spare tail write lock (slot 7). When set, no SPARE_TAIL element is writable.";
        } spare_tail_write_lock[14:14] = 0x0;

        field {
            sw = rw;
            onwrite = woset;
            hw = r;
            desc = "Spare tail read lock (slot 7). When set, no SPARE_TAIL element is readable.";
        } spare_tail_read_lock[15:15] = 0x0;
    };

    // SUPPLEMENTARY_LOCKS holds one write/read pair per supplementary lock region, at bits 2n and 2n+1 of
    // pair n. Pair n governs the n-th region of the supplementary fuse region; pairs beyond the last
    // region are unused.
    reg SUPPLEMENTARY_LOCKS {
        desc = "Lock controls for the supplementary fuse region. When write locked, the corresponding
                supplementary lock region is not programmable. When read locked, its shadow register is
                not readable.";

        field {
            sw = rw;
            onwrite = woset;
            hw = r;
            desc = "Supplementary region 0 write lock. When set, supplementary lock region 0 is not writable.";
        } region0_write_lock[0:0] = 0x0;

        field {
            sw = rw;
            onwrite = woset;
            hw = r;
            desc = "Supplementary region 0 read lock. When set, supplementary lock region 0 is not readable.";
        } region0_read_lock[1:1] = 0x0;

        field {
            sw = rw;
            onwrite = woset;
            hw = r;
            desc = "Supplementary region 1 write lock. When set, supplementary lock region 1 is not writable.";
        } region1_write_lock[2:2] = 0x0;

        field {
            sw = rw;
            onwrite = woset;
            hw = r;
            desc = "Supplementary region 1 read lock. When set, supplementary lock region 1 is not readable.";
        } region1_read_lock[3:3] = 0x0;

        field {
            sw = rw;
            onwrite = woset;
            hw = r;
            desc = "Supplementary region 2 write lock. When set, supplementary lock region 2 is not writable.";
        } region2_write_lock[4:4] = 0x0;

        field {
            sw = rw;
            onwrite = woset;
            hw = r;
            desc = "Supplementary region 2 read lock. When set, supplementary lock region 2 is not readable.";
        } region2_read_lock[5:5] = 0x0;

        field {
            sw = rw;
            onwrite = woset;
            hw = r;
            desc = "Supplementary region 3 write lock. When set, supplementary lock region 3 is not writable.";
        } region3_write_lock[6:6] = 0x0;

        field {
            sw = rw;
            onwrite = woset;
            hw = r;
            desc = "Supplementary region 3 read lock. When set, supplementary lock region 3 is not readable.";
        } region3_read_lock[7:7] = 0x0;

        field {
            sw = rw;
            onwrite = woset;
            hw = r;
            desc = "Supplementary region 4 write lock. When set, supplementary lock region 4 is not writable.";
        } region4_write_lock[8:8] = 0x0;

        field {
            sw = rw;
            onwrite = woset;
            hw = r;
            desc = "Supplementary region 4 read lock. When set, supplementary lock region 4 is not readable.";
        } region4_read_lock[9:9] = 0x0;

        field {
            sw = rw;
            onwrite = woset;
            hw = r;
            desc = "Supplementary region 5 write lock. When set, supplementary lock region 5 is not writable.";
        } region5_write_lock[10:10] = 0x0;

        field {
            sw = rw;
            onwrite = woset;
            hw = r;
            desc = "Supplementary region 5 read lock. When set, supplementary lock region 5 is not readable.";
        } region5_read_lock[11:11] = 0x0;

        field {
            sw = rw;
            onwrite = woset;
            hw = r;
            desc = "Supplementary region 6 write lock. When set, supplementary lock region 6 is not writable.";
        } region6_write_lock[12:12] = 0x0;

        field {
            sw = rw;
            onwrite = woset;
            hw = r;
            desc = "Supplementary region 6 read lock. When set, supplementary lock region 6 is not readable.";
        } region6_read_lock[13:13] = 0x0;

        field {
            sw = rw;
            onwrite = woset;
            hw = r;
            desc = "Supplementary region 7 write lock. When set, supplementary lock region 7 is not writable.";
        } region7_write_lock[14:14] = 0x0;

        field {
            sw = rw;
            onwrite = woset;
            hw = r;
            desc = "Supplementary region 7 read lock. When set, supplementary lock region 7 is not readable.";
        } region7_read_lock[15:15] = 0x0;

        field {
            sw = rw;
            onwrite = woset;
            hw = r;
            desc = "Supplementary region 8 write lock. When set, supplementary lock region 8 is not writable.";
        } region8_write_lock[16:16] = 0x0;

        field {
            sw = rw;
            onwrite = woset;
            hw = r;
            desc = "Supplementary region 8 read lock. When set, supplementary lock region 8 is not readable.";
        } region8_read_lock[17:17] = 0x0;

        field {
            sw = rw;
            onwrite = woset;
            hw = r;
            desc = "Supplementary region 9 write lock. When set, supplementary lock region 9 is not writable.";
        } region9_write_lock[18:18] = 0x0;

        field {
            sw = rw;
            onwrite = woset;
            hw = r;
            desc = "Supplementary region 9 read lock. When set, supplementary lock region 9 is not readable.";
        } region9_read_lock[19:19] = 0x0;

        field {
            sw = rw;
            onwrite = woset;
            hw = r;
            desc = "Supplementary region 10 write lock. When set, supplementary lock region 10 is not writable.";
        } region10_write_lock[20:20] = 0x0;

        field {
            sw = rw;
            onwrite = woset;
            hw = r;
            desc = "Supplementary region 10 read lock. When set, supplementary lock region 10 is not readable.";
        } region10_read_lock[21:21] = 0x0;

        field {
            sw = rw;
            onwrite = woset;
            hw = r;
            desc = "Supplementary region 11 write lock. When set, supplementary lock region 11 is not writable.";
        } region11_write_lock[22:22] = 0x0;

        field {
            sw = rw;
            onwrite = woset;
            hw = r;
            desc = "Supplementary region 11 read lock. When set, supplementary lock region 11 is not readable.";
        } region11_read_lock[23:23] = 0x0;

        field {
            sw = rw;
            onwrite = woset;
            hw = r;
            desc = "Supplementary region 12 write lock. When set, supplementary lock region 12 is not writable.";
        } region12_write_lock[24:24] = 0x0;

        field {
            sw = rw;
            onwrite = woset;
            hw = r;
            desc = "Supplementary region 12 read lock. When set, supplementary lock region 12 is not readable.";
        } region12_read_lock[25:25] = 0x0;

        field {
            sw = rw;
            onwrite = woset;
            hw = r;
            desc = "Supplementary region 13 write lock. When set, supplementary lock region 13 is not writable.";
        } region13_write_lock[26:26] = 0x0;

        field {
            sw = rw;
            onwrite = woset;
            hw = r;
            desc = "Supplementary region 13 read lock. When set, supplementary lock region 13 is not readable.";
        } region13_read_lock[27:27] = 0x0;

        field {
            sw = rw;
            onwrite = woset;
            hw = r;
            desc = "Supplementary region 14 write lock. When set, supplementary lock region 14 is not writable.";
        } region14_write_lock[28:28] = 0x0;

        field {
            sw = rw;
            onwrite = woset;
            hw = r;
            desc = "Supplementary region 14 read lock. When set, supplementary lock region 14 is not readable.";
        } region14_read_lock[29:29] = 0x0;

        field {
            sw = rw;
            onwrite = woset;
            hw = r;
            desc = "Supplementary region 15 write lock. When set, supplementary lock region 15 is not writable.";
        } region15_write_lock[30:30] = 0x0;

        field {
            sw = rw;
            onwrite = woset;
            hw = r;
            desc = "Supplementary region 15 read lock. When set, supplementary lock region 15 is not readable.";
        } region15_read_lock[31:31] = 0x0;

        field {
            sw = rw;
            onwrite = woset;
            hw = r;
            desc = "Supplementary region 16 write lock. When set, supplementary lock region 16 is not writable.";
        } region16_write_lock[32:32] = 0x0;

        field {
            sw = rw;
            onwrite = woset;
            hw = r;
            desc = "Supplementary region 16 read lock. When set, supplementary lock region 16 is not readable.";
        } region16_read_lock[33:33] = 0x0;

        field {
            sw = rw;
            onwrite = woset;
            hw = r;
            desc = "Supplementary region 17 write lock. When set, supplementary lock region 17 is not writable.";
        } region17_write_lock[34:34] = 0x0;

        field {
            sw = rw;
            onwrite = woset;
            hw = r;
            desc = "Supplementary region 17 read lock. When set, supplementary lock region 17 is not readable.";
        } region17_read_lock[35:35] = 0x0;

        field {
            sw = rw;
            onwrite = woset;
            hw = r;
            desc = "Supplementary region 18 write lock. When set, supplementary lock region 18 is not writable.";
        } region18_write_lock[36:36] = 0x0;

        field {
            sw = rw;
            onwrite = woset;
            hw = r;
            desc = "Supplementary region 18 read lock. When set, supplementary lock region 18 is not readable.";
        } region18_read_lock[37:37] = 0x0;

        field {
            sw = rw;
            onwrite = woset;
            hw = r;
            desc = "Supplementary region 19 write lock. When set, supplementary lock region 19 is not writable.";
        } region19_write_lock[38:38] = 0x0;

        field {
            sw = rw;
            onwrite = woset;
            hw = r;
            desc = "Supplementary region 19 read lock. When set, supplementary lock region 19 is not readable.";
        } region19_read_lock[39:39] = 0x0;

        field {
            sw = rw;
            onwrite = woset;
            hw = r;
            desc = "Supplementary region 20 write lock. When set, supplementary lock region 20 is not writable.";
        } region20_write_lock[40:40] = 0x0;

        field {
            sw = rw;
            onwrite = woset;
            hw = r;
            desc = "Supplementary region 20 read lock. When set, supplementary lock region 20 is not readable.";
        } region20_read_lock[41:41] = 0x0;

        field {
            sw = rw;
            onwrite = woset;
            hw = r;
            desc = "Supplementary region 21 write lock. When set, supplementary lock region 21 is not writable.";
        } region21_write_lock[42:42] = 0x0;

        field {
            sw = rw;
            onwrite = woset;
            hw = r;
            desc = "Supplementary region 21 read lock. When set, supplementary lock region 21 is not readable.";
        } region21_read_lock[43:43] = 0x0;

        field {
            sw = rw;
            onwrite = woset;
            hw = r;
            desc = "Supplementary region 22 write lock. When set, supplementary lock region 22 is not writable.";
        } region22_write_lock[44:44] = 0x0;

        field {
            sw = rw;
            onwrite = woset;
            hw = r;
            desc = "Supplementary region 22 read lock. When set, supplementary lock region 22 is not readable.";
        } region22_read_lock[45:45] = 0x0;

        field {
            sw = rw;
            onwrite = woset;
            hw = r;
            desc = "Supplementary region 23 write lock. When set, supplementary lock region 23 is not writable.";
        } region23_write_lock[46:46] = 0x0;

        field {
            sw = rw;
            onwrite = woset;
            hw = r;
            desc = "Supplementary region 23 read lock. When set, supplementary lock region 23 is not readable.";
        } region23_read_lock[47:47] = 0x0;

        field {
            sw = rw;
            onwrite = woset;
            hw = r;
            desc = "Supplementary region 24 write lock. When set, supplementary lock region 24 is not writable.";
        } region24_write_lock[48:48] = 0x0;

        field {
            sw = rw;
            onwrite = woset;
            hw = r;
            desc = "Supplementary region 24 read lock. When set, supplementary lock region 24 is not readable.";
        } region24_read_lock[49:49] = 0x0;

        field {
            sw = rw;
            onwrite = woset;
            hw = r;
            desc = "Supplementary region 25 write lock. When set, supplementary lock region 25 is not writable.";
        } region25_write_lock[50:50] = 0x0;

        field {
            sw = rw;
            onwrite = woset;
            hw = r;
            desc = "Supplementary region 25 read lock. When set, supplementary lock region 25 is not readable.";
        } region25_read_lock[51:51] = 0x0;

        field {
            sw = rw;
            onwrite = woset;
            hw = r;
            desc = "Supplementary region 26 write lock. When set, supplementary lock region 26 is not writable.";
        } region26_write_lock[52:52] = 0x0;

        field {
            sw = rw;
            onwrite = woset;
            hw = r;
            desc = "Supplementary region 26 read lock. When set, supplementary lock region 26 is not readable.";
        } region26_read_lock[53:53] = 0x0;

        field {
            sw = rw;
            onwrite = woset;
            hw = r;
            desc = "Supplementary region 27 write lock. When set, supplementary lock region 27 is not writable.";
        } region27_write_lock[54:54] = 0x0;

        field {
            sw = rw;
            onwrite = woset;
            hw = r;
            desc = "Supplementary region 27 read lock. When set, supplementary lock region 27 is not readable.";
        } region27_read_lock[55:55] = 0x0;

        field {
            sw = rw;
            onwrite = woset;
            hw = r;
            desc = "Supplementary region 28 write lock. When set, supplementary lock region 28 is not writable.";
        } region28_write_lock[56:56] = 0x0;

        field {
            sw = rw;
            onwrite = woset;
            hw = r;
            desc = "Supplementary region 28 read lock. When set, supplementary lock region 28 is not readable.";
        } region28_read_lock[57:57] = 0x0;

        field {
            sw = rw;
            onwrite = woset;
            hw = r;
            desc = "Supplementary region 29 write lock. When set, supplementary lock region 29 is not writable.";
        } region29_write_lock[58:58] = 0x0;

        field {
            sw = rw;
            onwrite = woset;
            hw = r;
            desc = "Supplementary region 29 read lock. When set, supplementary lock region 29 is not readable.";
        } region29_read_lock[59:59] = 0x0;

        field {
            sw = rw;
            onwrite = woset;
            hw = r;
            desc = "Supplementary region 30 write lock. When set, supplementary lock region 30 is not writable.";
        } region30_write_lock[60:60] = 0x0;

        field {
            sw = rw;
            onwrite = woset;
            hw = r;
            desc = "Supplementary region 30 read lock. When set, supplementary lock region 30 is not readable.";
        } region30_read_lock[61:61] = 0x0;

        field {
            sw = rw;
            onwrite = woset;
            hw = r;
            desc = "Supplementary region 31 write lock. When set, supplementary lock region 31 is not writable.";
        } region31_write_lock[62:62] = 0x0;

        field {
            sw = rw;
            onwrite = woset;
            hw = r;
            desc = "Supplementary region 31 read lock. When set, supplementary lock region 31 is not readable.";
        } region31_read_lock[63:63] = 0x0;
    };

    reg JTAG_PUBLIC_IDENTITY {
        desc = "JTAG-public exception window. In PROD and RMA_SiP, JTAG reads of this range
                are admitted while every JTAG write and every other JTAG read is blocked. When
                the lifecycle state fails its integrity check, JTAG reads of this range are
                blocked as well. Encoding
                is adopter-defined; the harness does not interpret or consume the value. The
                slot-0 read lock still hides the bits when set.";
        regwidth = 256;

        field {
            sw = rw;
            hw = r;
            desc = "Opaque payload. Encoding is adopter-defined; the harness does not interpret
                    it.";
        } value [255:0] = 0x0;
    };

    reg I2C_I3C_ID {
        desc = "I2C/I3C interface ID";
        regwidth = 64;

        field {
            sw = rw;
            hw = r;
            desc = "I2C or I3C ID configuration:
                   * Static ID mode: [6:0] contains ID, [63:7] reserved
                   * Provisional ID mode: [63:0] full ID";
        } interface_id[63:0] = 0x0;
    };

    reg SMC_CONFIG {
        desc = "SMC boot and configuration controls sourced from fuse. Only the low word carries
                assigned bits, so firmware reads it as a single 32-bit access.";
        regwidth = 64;

        field {
            sw = rw;
            hw = r;
            desc = "When set, the ROM interface swaps byte order on instruction fetch.";
        } rom_flip_endianness[0:0] = 0x0;

        field {
            sw = rw;
            hw = r;
            desc = "Reserved for future configuration bits.";
        } config_rsvd_low[6:1] = 0x0;

        field {
            sw = rw;
            hw = r;
            desc = "When set, boot skips the SRAM auto-zero initialisation pass.";
        } sram_auto_zero_disable[7:7] = 0x0;

        field {
            sw = rw;
            hw = r;
            desc = "Reserved for future configuration bits.";
        } config_rsvd_mid[14:8] = 0x0;

        field {
            sw = rw;
            hw = r;
            desc = "When set, boot continues despite a reported memory repair or MBIST failure.";
        } dft_ignore_error[15:15] = 0x0;

        field {
            sw = rw;
            hw = r;
            desc = "Reserved for future configuration bits.";
        } config_rsvd_high[63:16] = 0x0;
    };

    reg OCCP_TRANSPORT_TIMEOUT {
        desc = "OCCP transport timeout in the low word; upper word reserved.";
        regwidth = 64;

        field {
            sw = rw;
            hw = r;
            desc = "Transport timeout value consumed by the boot ROM OCCP driver.";
        } timeout[31:0] = 0x0;

        field {
            sw = rw;
            hw = r;
            desc = "Reserved for extension of the timeout encoding.";
        } timeout_rsvd[63:32] = 0x0;
    };

    reg SPARE_256_BITS {
        desc = "Individually lockable 256-bit spare region, reserved for fields assigned after the
                RTL is frozen. Each element has its own write/read lock pair in HARNESS_LOCKS.";
        regwidth = 256;

        field {
            sw = rw;
            hw = r;
            desc = "Spare fuse bits for future use.";
        } rsvd[255:0] = 0x0;
    };

    reg SPARE_64_BITS {
        desc = "64-bit spare region at the end of the map, reserved for fields assigned after the
                RTL is frozen. All elements share the slot-7 write/read lock pair in
                HARNESS_LOCKS.";
        regwidth = 64;

        field {
            sw = rw;
            hw = r;
            desc = "Spare fuse bits for future use.";
        } rsvd[63:0] = 0x0;
    };

    /////////////////
    // Address Map //
    /////////////////

    // Sizes total 8 + 8 + 32 + 72 + 8 + 8 + 96 + 24 = 256 B, ending at 0xFF.
    HARNESS_LOCKS           HARNESS_LOCKS           @ 0x0;
    SUPPLEMENTARY_LOCKS     SUPPLEMENTARY_LOCKS     @ 0x8;
    JTAG_PUBLIC_IDENTITY    JTAG_PUBLIC_IDENTITY    @ 0x10;
    I2C_I3C_ID              I2C_I3C_ID[9]           @ 0x30;
    SMC_CONFIG              SMC_CONFIG              @ 0x78;
    OCCP_TRANSPORT_TIMEOUT  OCCP_TRANSPORT_TIMEOUT  @ 0x80;
    SPARE_256_BITS          SPARE[3]                @ 0x88;
    SPARE_64_BITS           SPARE_TAIL[3]           @ 0xE8;

};

`endif
