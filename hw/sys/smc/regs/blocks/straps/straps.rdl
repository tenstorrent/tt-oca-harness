// SPDX-License-Identifier: Apache-2.0
// SPDX-FileCopyrightText: 2026 Tenstorrent USA, Inc.

`ifndef STRAPS_RDL_DEFINED
`define STRAPS_RDL_DEFINED

// Captured GPIO strap values, presented to firmware as two read-only words.

addrmap straps {

    desc = "Captured GPIO strap values (adopter padring capture)";

    ////////////////////////////////////////////////////////////////////////////
    // Register Definitions
    ////////////////////////////////////////////////////////////////////////////

    // Strap assignments below mirror the Strap / Strap Notes columns of the GPIO
    // pin table; keep them in sync when a strap moves to a different pad.
    reg STRAPS_LO {
        regwidth = 32;
        accesswidth = 32;

        field {
            sw = r;
            hw = w;
            desc = "Strap value from GPIOs 0 - 31. Bit N holds the value latched on GPIO N.
                    Bits 0 - 10, 16, 17, 24 and 27 - 31 have no strap assigned. Those GPIOs still
                    latch their pad value here, but no strap function consumes it.
                    Strap assignments in this range:
                    * bit 11: CHIP_ID[3] - CHIP_ID is the I2C/I3C static address strap
                    * bit 12: CHIP_ID[2] - CHIP_ID is the I2C/I3C static address strap
                    * bit 13: BYPASS_SRAM_REPAIR - Bypass the memory repair process
                    * bit 14: TEST_EN - Enable DFT test mode
                    * bit 15: CHIP_ID[1] - CHIP_ID is the I2C/I3C static address strap
                    * bit 18: BOOT_I2C - Default alternate boot channel is I3C0 and can be reconfigured to use I2C0
                    * bit 19: BOOT_RECOVERY - Use I3C0 for BL1 boot image loading instead of the SPI channel
                    * bit 20: BL0_PLLCLK - Use the PLL generated clock by default in BL0, and override to use the reference clock when this strap is asserted
                    * bit 21: STATUS_RPT_DISABLE - Disable BL0 status reporting. It is on by default
                    * bit 22: SPI_USE_FUSED_CONFIG - Use the SPI configuration values stored in the fuse field
                    * bit 23: CHIP_ID[0] - CHIP_ID is the I2C/I3C static address strap
                    * bit 25: PRIMARY_CHIPLET - The primary chiplet has this strap bonded out to identify it as the boot master
                    * bit 26: SRAM_AUTO_ZERO_DISABLE - Disable auto zero of the SMC SRAM when asserted";
        } straps[31:0] = 0x0;
    };

    // Width is smc_pkg::NUM_BONDED_GPIO-32 (61-32 = 29). RDL cannot import smc_pkg,
    // so this must be updated by hand if the bonded GPIO count changes.
    reg STRAPS_HI {
        regwidth = 32;
        accesswidth = 32;

        field {
            sw = r;
            hw = w;
            desc = "Strap value from GPIOs 32 - 60. Bit N holds the value latched on GPIO N+32.
                    All bits other than those listed below have no strap assigned. Those GPIOs
                    still latch their pad value here, but no strap function consumes it.
                    GPIOs 61 - 64 cannot be strapped: they are unbonded (not packaged out) and lie
                    outside this register, which ends at GPIO 60 (smc_pkg::NUM_BONDED_GPIO-1).
                    Strap assignments in this range:
                    * bit 22 (GPIO 54): MBIST_BYPASS - Ignore results of Power-On MBIST for boot
                    * bit 26 (GPIO 58): ROTATE_UPDATE - Swaps primary and backup image in SEP BL0 ROM";
        } straps[28:0] = 0x0;
    };

    // --------------------------------------------------
    // Address Map
    //
    // STRAPS_HI must stay at STRAPS_LO + 4: firmware and DV both read the pair as
    // one 64-bit access at the STRAPS_LO address.
    // --------------------------------------------------

    STRAPS_LO                       STRAPS_LO               @ 0x0;
    STRAPS_HI                       STRAPS_HI               @ 0x4;

};

`endif
