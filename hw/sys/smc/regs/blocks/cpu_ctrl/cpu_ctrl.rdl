`ifndef CPU_CTRL_RDL_DEFINED
`define CPU_CTRL_RDL_DEFINED

addrmap cpu_ctrl {

    reg RESET_VECTOR{
        regwidth = 64;
        accesswidth = 64;

        field {
            sw=rw;
            hw=r;
        } vector [55:0] = 0xc004_0000;
    };

    reg RESET_CTRL {
        regwidth = 64;
        accesswidth = 64;

        field  {
            sw=rw;
            hw=r;
            desc="Reset control for the CPU, active low.";
        } core0_reset_n_n0_scan [0:0] = 0x1;

        field  {
            sw=rw;
            hw=r;
            desc="Reset control for the CPU, active low.";
        } core1_reset_n_n0_scan [1:1] = 0x1;

        field  {
            sw=rw;
            hw=r;
            desc="Reset control for the CPU, active low.";
        } core2_reset_n_n0_scan [2:2] = 0x1;

        field  {
            sw=rw;
            hw=r;
            desc="Reset control for the CPU, active low.";
        } core3_reset_n_n0_scan [3:3] = 0x1;

        field {
            sw=rw;
            hw=r;
            desc = "Writing a 1 to this register triggers a core reset pulse, the duration of which is set by CORE_RESET_PULSE_COUNT.
                    This pulse is ANDed with core_reset_n[0] so a 0 in core_reset_n[0] will override the pulse.";
        } core0_reset_pulse_start_n0_scan[4:4] = 0x0;

        field {
            sw=rw;
            hw=r;
            desc = "Writing a 1 to this register triggers a core reset pulse, the duration of which is set by CORE_RESET_PULSE_COUNT.
                    This pulse is ANDed with core_reset_n[1] so a 0 in core_reset_n[1] will override the pulse.";
        } core1_reset_pulse_start_n0_scan[5:5] = 0x0;

        field {
            sw=rw;
            hw=r;
            desc = "Writing a 1 to this register triggers a core reset pulse, the duration of which is set by CORE_RESET_PULSE_COUNT.
                    This pulse is ANDed with core_reset_n[2] so a 0 in core_reset_n[2] will override the pulse.";
        } core2_reset_pulse_start_n0_scan[6:6] = 0x0;

        field {
            sw=rw;
            hw=r;
            desc = "Writing a 1 to this register triggers a core reset pulse, the duration of which is set by CORE_RESET_PULSE_COUNT.
                    This pulse is ANDed with core_reset_n[3] so a 0 in core_reset_n[3] will override the pulse.";
        } core3_reset_pulse_start_n0_scan[7:7] = 0x0;

        field {
            sw=rw;
            hw=r;
            desc="Cluster Uncore Reset, active low. Writing this register will only reset the uncore portion in the chipyard cluster.
                  WARNING: using this can cause any outstanding axi requests to and from the cluster to cause timeouts/exceptions.";
        } uncore_reset_n_n0_scan [8:8] = 0x1;

        field {
            sw=rw;
            hw=r;
            desc="Debug Module Reset, active low";
        } debug_reset_n_n0_scan [24:24] = 0x0;
    };

    reg CORE_RESET_PULSE_COUNT {
        regwidth = 64;
        accesswidth = 64;

        field  {
            sw=rw;
            hw=r;
            desc="Core reset pulse count pre-reset. The duration of the pulse is the set value + 1.";
        } pre_reset_count [15:0] = 0x8;

        field  {
            sw=rw;
            hw=r;
            desc="Core reset pulse count post-reset. The duration of the pulse is the set value + 1.";
        } post_reset_count [31:16] = 0x10;

        field {
            sw=r;
            hw=w;
            desc="Logic low while performing core reset, logic high otherwise.";
        } core_resets_done [35:32] = 0xf;

    };

    reg RESET_TIMEOUT {
        regwidth = 64;
        accesswidth = 64;

        field {
            sw=rw;
            hw=r;
            desc="Cycles (clk_smc) a software reset may stay pending (withheld, waiting
                  for drain) before timeout. 0 = disabled, wait indefinitely.";
        } timeout_value [15:0] = 0x0;

        field {
            sw=rw;
            hw=r;
            desc="Timeout mode: 0 = give up and report error (stay withheld, do not apply);
                  1 = force the reset on timeout.";
        } timeout_mode [16:16] = 0x0;

        field {
            sw=r;
            hw=w;
            desc="Live status: high while a requested software reset is actually applied
                  at the cluster (drain complete and reset asserted).";
        } reset_applied [32:32] = 0x0;

        field {
            sw=r;
            hw=w;
            desc="Live status: high while a pending software reset has exceeded
                  timeout_value (timeout/error flag; set in both modes).";
        } reset_timeout [36:36] = 0x0;
    };

    reg GLOBAL_BASE {
        regwidth = 64;
        accesswidth = 64;

        field  {
            sw=rw;
            hw=r;
            desc="Global base address for the CPU. Defaults to 0x0";
        } base [55:0] = 0x4000_0000;
    };

    reg LOCAL_BASE {
        regwidth = 64;
        accesswidth = 64;

        field  {
            sw=r;
            hw=r;
            desc="Local base address for the CPU. Defaults to 0xC000_0000";
        } base [55:0] = 0xC000_0000;
    };

    reg REGION_SIZE {
        regwidth = 64;
        accesswidth = 64;

        field {
            sw = rw;
            hw = r;
            desc = "Region size for SMC resources. Defaults to 16MB (0x100_0000); FW reprograms per chiplet spec.";
        } size [31:0] = 0x100_0000;
    };

    reg REFERENCE_COUNTER {
        regwidth = 64;
        accesswidth = 64;

        field  {
            sw=rw;
            hw=rw;
            wr_swacc = true;
            desc="Reference counter for the CPU";
        } rc [63:0] = 0x0;
    };


    reg WDT_TIMEOUT {
        field  {
            sw=rw;
            hw=r;
            desc="Cycle count value that 2nd stage watchdog timer timeout should occur at. Defaults to 16384 cycles";
        } data [31:0] = 0x4000;
    };

    reg WDT_TIMEOUT_RESET {
        field  {
            sw=rw;
            hw=r;
            singlepulse=true;
            desc="Reset current cycle count value in 2nd stage watchdog timer";
        } reset_cycle_count_0 [0:0] = 0x0;

        field  {
            sw=rw;
            hw=r;
            singlepulse=true;
            desc="Reset current cycle count value in 2nd stage watchdog timer";
        } reset_cycle_count_1 [1:1] = 0x0;

        field  {
            sw=rw;
            hw=r;
            singlepulse=true;
            desc="Reset current cycle count value in 2nd stage watchdog timer";
        } reset_cycle_count_2 [2:2] = 0x0;

        field  {
            sw=rw;
            hw=r;
            singlepulse=true;
            desc="Reset current cycle count value in 2nd stage watchdog timer";
        } reset_cycle_count_3 [3:3] = 0x0;
    };


    reg CLOCK_GATE_CONTROL {
        regwidth = 64;
        accesswidth = 64;

        field  {
            sw=rw;
            hw=r;
            desc="Clockgate enable for the DMA";
        } dma_cg_en [0:0] = 0x0;

        field  {
            sw=rw;
            hw=r;
            desc="Clockgate enable for the mailbox";
        } mailbox_cg_en [1:1] = 0x0;

        field  {
            sw=rw;
            hw=r;
            desc="Clockgate enable for the outbound filters";
        } filter_ob_axi_cg_en [2:2] = 0x0;

        field  {
            sw=rw;
            hw=r;
            desc="Clockgate enable for outbound filter registers";
        } filter_ob_reg_cg_en [3:3] = 0x0;

        field  {
            sw=rw;
            hw=r;
            desc="Clockgate enable for the inbound filters";
        } filter_ib_axi_cg_en [4:4] = 0x0;

        field  {
            sw=rw;
            hw=r;
            desc="Clockgate enable for inbound filter registers";
        } filter_ib_reg_cg_en [5:5] = 0x0;

        field {
            sw=rw;
            hw=r;
            desc="Clock gate enable for address remapper register logic";
        } addr_remap_cg_en [6:6] = 0x0;

        field {
            sw=rw;
            hw=r;
            desc="Clock gate enable for address remapper register logic";
        } output_fabric_cg_en [7:7] = 0x0;

        field {
            sw=rw;
            hw=r;
            desc="Clock gate enable for axi zeroer";
        } zeroer_cg_en [8:8] = 0x0;

        field {
            sw=rw;
            hw=r;
            desc="Clock gate enable for i3c";
        } i3c_cg_en [9:9] = 0x0;

        field {
            sw=rw;
            hw=r;
            desc="Clock gate enable for AVSBus";
        } avs_cg_en [10:10] = 0x0;

        field {
            sw=rw;
            hw=r;
            desc="Clock gate enable for i2c";
        } i2c_cg_en [11:11] = 0x0;

        field {
            sw=rw;
            hw=r;
            desc="Clock gate enable for UART";
        } uart_cg_en [12:12] = 0x0;

        field {
            sw=rw;
            hw=r;
            desc="Clock gate enable for telemetry";
        } telemetry_cg_en [13:13] = 0x0;

        field {
            sw=rw;
            hw=r;
            desc="Clockgate cg_hysteresis";
        } cg_hysteresis [29:24] = 0x1f;
    };

    reg SCRATCH {
        regwidth = 64;
        accesswidth = 64;

        field  {
            sw=rw;
            hw=r;
            desc="Scratch register for the CPU";
        } data [31:0] = 0x0;
    };

    reg SMC_ATTRIBUTES {
        regwidth = 64;
        accesswidth = 64;

        field {
            hw = w;
            sw = r;
            desc = "Indicates if this chiplet is primary (1) or secondary (0). Driven by strap.";
        } chiplet_is_primary[0:0];
        field {
            hw = w;
            sw = r;
        } num_ext_interrupts[16:8];
        field {
            hw = w;
            sw = r;
        } num_cpu_interrupts[25:17];
        field {
            hw = w;
            sw = r;
            desc = "Total SRAM size is 2 ^ value bytes";
        } sram_size[31:26];
        field {
            hw = w;
            sw = r;
        } no_output_remap[32:32];
        field {
            hw = w;
            sw = r;
        } num_cores[35:33];
        field {
            hw = w;
            sw = r;
        } mailbox_depth[39:36];
        field {
            hw = w;
            sw = r;
        } num_mailboxes[45:40];
    };

    reg TEST_CTRL {
        regwidth = 64;
        accesswidth = 64;

        field  {
            sw=r;
            hw=w;
            desc="Test control register for the CPU";
        } data [31:0] = 0x0;
    };

    reg DEBUG_CTRL {
        regwidth = 32;
        accesswidth = 32;

        field {
            sw=rw;
            hw=r;
            desc="Chiplet Enable Used for Triggering";
        } chiplet_enable [1:0] = 0x0;

        field {
            sw=rw;
            hw=r;
            desc="GPIO en";
        }  gpio_en[2:2] = 0x0;

        field {
            sw=rw;
            hw=r;
            desc="Clock gating en";
        }  cg_en[3:3] = 0x0;

        field {
            sw=rw;
            hw=r;
            desc="Force clk en";
        } force_clk_en[4:4] = 0x0;

        field {
            sw=rw;
            hw=r;
            desc="DTB NS enable";
        } dtb_ns_en[5:5] = 0x0;

        field {
            sw=rw;
            hw=r;
            desc="DTB E/W enable";
        } dtb_ew_en[6:6] = 0x0;

        field {
            sw=rw;
            hw=r;
            desc="Mask==0 (default) -> disabled; Mask==1 -> enabled";
        } xtrig_clk_halt_mask[22:7] = 0x0;

        field {
            sw=rw;
            hw=r;
            desc="Debug marker";
        } debug_marker [30:23] = 0x0;

    };

    reg DEBUG_BUS_MUX {
        desc = "";
        regwidth = 0x40;

        field {
            desc = "Mode selection, 0: DBM off, 1: Normal debug mode, 2: DBM ID output mode, 3: Toggle Mode";
            sw = rw;
            hw = r;

        } Dbmmode[1:0] = 0x0;
        field {
            desc = "Unique DBM ID of the DBM instance";
            sw = rw;
            hw = r;

        } Dbmid[7:2] = 0x0;
        field {
            sw = rw;
            hw = r;

        } Rsvd158[15:8] = 0x0;
        field {
            desc = "Mux Select Bits for Lane 0. Split debug bus into 16 bit segments. Seg0 = debug bus [15:0], Seg1 = debug bus[31:16],.... If all bits are 0, Lane0 = Seg0, if bit[0] = 1, Lane0 = Seg4, if bit[1] =1, Lane0 = Seg5,...";
            sw = rw;
            hw = r;

        } Muxselseg0[21:16] = 0x0;
        field {
            desc = "Mux Select Bits for Lane 1. Split debug bus into 16 bit segments. Seg0 = debug bus [15:0], Seg1 = debug bus[31:16],.... If all bits are 0, Lane1= Seg1, if bit[0] = 1, Lane1 = Seg4, if bit[1] =1, Lane1 = Seg5,...";
            sw = rw;
            hw = r;

        } Muxselseg1[27:22] = 0x0;
        field {
            desc = "Mux Select Bits for Lane 2. Split debug bus into 16 bit segments. Seg0 = debug bus [15:0], Seg1 = debug bus[31:16],.... If all bits are 0, Lane2= Seg2, if bit[0] = 1, Lane2 = Seg4, if bit[1] =1, Lane2 = Seg5,...";
            sw = rw;
            hw = r;

        } Muxselseg2[33:28] = 0x0;
        field {
            desc = "Mux Select Bits for Lane 3. Split debug bus into 16 bit segments. Seg0 = debug bus [15:0], Seg1 = debug bus[31:16],.... If all bits are 0, Lane3= Seg3, if bit[0] = 1, Lane3 = Seg4, if bit[1] =1, Lane3 = Seg5,...";
            sw = rw;
            hw = r;

        } Muxselseg3[39:34] = 0x0;
        field {
            sw = rw;
            hw = r;

        } Muxselseg4[45:40] = 0x0;
        field {
            sw = rw;
            hw = r;

        } Muxselseg5[51:46] = 0x0;
        field {
            sw = rw;
            hw = r;

        } Muxselseg6[57:52] = 0x0;
        field {
            sw = rw;
            hw = r;

        } Muxselseg7[63:58] = 0x0;
    };

    reg WB_PC {
        regwidth = 64;
        accesswidth = 64;

        field {
            sw=r;
            hw=w;
            desc="Writeback PC value";
        } pc[57:0] = 0x0;
    };

    reg MUTEX {
        regwidth = 64;
        accesswidth = 64;

        field {
            sw = rw;
            hw = w;
            rd_swacc = true;
            wr_swacc = true;
            desc = "HW mutex. Reads will attempt to acquire mutex, 1 on success. If the mutex is already acquired, the read will return 0. To release the mutex, write any value to the register.";
        } mutex[0:0] = 0x1;
    };

    reg SEMA {
        regwidth = 64;
        accesswidth = 64;

        field {
            sw = rw;
            hw = r;
            desc = "16-bit semaphore value to inc/dec. Writing to this register will inc/dec the semaphore value.
                    The written value is treated as a signed number using 2s compliment.";
        } sema[15:0] = 0x0;
    };

    reg DUMMY_ROM_0{
        regwidth = 64;
        accesswidth = 64;

        field {
            sw=rw;
            hw=r;
            desc="Word 0 of WFI loop";
        } dummy_rom_word_0 [63:0] = 0x0145051300000517;
    };

    reg DUMMY_ROM_1{
        regwidth = 64;
        accesswidth = 64;

        field {
            sw=rw;
            hw=r;
            desc="Word 1 of WFI loop";
        } dummy_rom_word_1 [63:0] = 0xfff0069330551073;
    };

    reg DUMMY_ROM_2{
        regwidth = 64;
        accesswidth = 64;

        field {
            sw=rw;
            hw=r;
            desc="Word 2 of WFI loop";
        } dummy_rom_word_2 [63:0] = 0x105000733046b073;
    };

    reg DUMMY_ROM_3{
        regwidth = 64;
        accesswidth = 64;

        field {
            sw=rw;
            hw=r;
            desc="Word 3 of WFI loop";
        } dummy_rom_word_3 [63:0] = 0x00000000ffdff06f;
    };

    reg DUMMY_ROM_NULL{
        regwidth = 64;
        accesswidth = 64;

        field {
            sw=rw;
            hw=r;
            desc="Cache line size is 64 bytes so want to ensure no random data is read when reading dummy rom";
        } dummy_rom_null [63:0] = 0x0;
    };

    // AXI hang detector registers (one CTRL + one TIMEOUT_THRESHOLD per
    // independent master). Fields are nibble-spaced so each maps to one hex
    // character. irq_o is a direct combinational level (no status latch).
    reg HANG_DET_CTRL {
        desc = "AXI hang detector control.";
        field {
            sw = rw; hw = r;
            desc = "When 1, the timeout counter runs. When 0, it is held at 0 and irq_o is forced low.";
        } enable[0:0] = 0x0;
        field {
            sw = rw; hw = r;
            desc = "Interrupt enable. When 1, a timeout event propagates to irq_o.";
        } irq_en[4:4] = 0x0;
        field {
            sw = rw; hw = r;
            desc = "Interrupt test. When 1, forces irq_o high for verification / firmware bring-up.";
        } irq_test[8:8] = 0x0;
    };

    reg HANG_DET_TIMEOUT_THRESHOLD {
        desc = "Consecutive cycles with outstanding AXI transactions and no completion before a timeout fires.";
        field {
            sw = rw; hw = r;
            desc = "Threshold in clock cycles. Default 0x1000. 20 bits => up to ~1M cycles (~1ms at 1GHz).";
        } value[19:0] = 0x1000;
    };

    // --------------------------------------------------

    // Core Specific Address Space 0x0 - 0x0ffff
    RESET_VECTOR                    RESET_VECTOR[4]                 @ 0x0;
    external RESET_CTRL             RESET_CTRL                      @ 0x20;
    CORE_RESET_PULSE_COUNT          CORE_RESET_PULSE_COUNT          @ 0x28;

    CLOCK_GATE_CONTROL              CLOCK_GATE_CONTROL              @ 0x30;

    RESET_TIMEOUT                   RESET_TIMEOUT                   @ 0x38;

    GLOBAL_BASE                     GLOBAL_BASE                     @ 0x40;
    LOCAL_BASE                      LOCAL_BASE                      @ 0x48;
    REGION_SIZE                     REGION_SIZE                     @ 0x50;

    REFERENCE_COUNTER               REFERENCE_COUNTER               @ 0x60;

    WDT_TIMEOUT                     WDT_TIMEOUT                     @ 0x70;
    WDT_TIMEOUT_RESET               WDT_TIMEOUT_RESET               @ 0x78;

    SCRATCH                         SCRATCH[16]                     @ 0x100;

    TEST_CTRL                       TEST_CTRL                       @ 0x200;
    DEBUG_CTRL                      DEBUG_CTRL                      @ 0x208;
    DEBUG_BUS_MUX                   DEBUG_BUS_MUX                   @ 0x210;

    WB_PC                           WB_PC_CORE0[8]                  @ 0x300;
    WB_PC                           WB_PC_CORE1[8]                  @ 0x340;
    WB_PC                           WB_PC_CORE2[8]                  @ 0x380;
    WB_PC                           WB_PC_CORE3[8]                  @ 0x3c0;

    // Generic Address Space 0x100 - 0xfff
    SMC_ATTRIBUTES                  SMC_ATTRIBUTES                  @ 0x1000;

    MUTEX                           MUTEX[4]                        @ 0x1040;
    external SEMA                   SEMA[4]                         @ 0x1060;

    DUMMY_ROM_0                     DUMMY_ROM_0                     @ 0x1180;
    DUMMY_ROM_1                     DUMMY_ROM_1                     @ 0x1188;
    DUMMY_ROM_2                     DUMMY_ROM_2                     @ 0x1190;
    DUMMY_ROM_3                     DUMMY_ROM_3                     @ 0x1198;
    DUMMY_ROM_NULL                  DUMMY_ROM_NULL[4]               @ 0x11A0;

    // AXI hang detectors, one per independent master AXI into the SMC fabric.
    HANG_DET_CTRL              HANG_DET_SYS_AXI_CTRL                  @ 0x1200;
    HANG_DET_TIMEOUT_THRESHOLD HANG_DET_SYS_AXI_TIMEOUT_THRESHOLD    @ 0x1208;
    HANG_DET_CTRL              HANG_DET_SEP_AXI_CTRL                  @ 0x1210;
    HANG_DET_TIMEOUT_THRESHOLD HANG_DET_SEP_AXI_TIMEOUT_THRESHOLD    @ 0x1218;
    HANG_DET_CTRL              HANG_DET_DATA_ACCEL_CTRL              @ 0x1220;
    HANG_DET_TIMEOUT_THRESHOLD HANG_DET_DATA_ACCEL_TIMEOUT_THRESHOLD @ 0x1228;
};

`endif