// SPDX-License-Identifier: Apache-2.0
// SPDX-FileCopyrightText: 2026 Tenstorrent USA, Inc.

`ifndef CLINT_REG_RDL
`define CLINT_REG_RDL

addrmap clint {
    name = "CLINT Address Map";
    desc = "Core-Local Interruptor: software-interrupt, timer-compare, and machine-time registers.";
    
    ////////////////////////////////////////////////////////////////////////////
    // Register Definitions
    ////////////////////////////////////////////////////////////////////////////

    reg MSIP {
        field {
            sw=rw; 
            hw=r;
            desc="MSIP bit for core";
        } value[0:0] = 0x0;

        field {
            sw=r;
            hw=r;
            desc="Reserved";
        } rsvd0[31:1] = 0x0;
    };

    reg MTIMECMP {
        regwidth = 64;
        accesswidth = 64;

        field {
            sw=rw; 
            hw=r;
            desc="Timer compare value. The core's machine timer interrupt is asserted while MTIME is greater than or equal to this value, and deasserts when software sets this value above MTIME. This register has no reset: its value, and therefore the level of the machine timer interrupt, is undefined until software writes it. Write it before enabling the machine timer interrupt.";
        } count[63:0];
    };

    reg MTIME {
        regwidth = 64;
        accesswidth = 64;

        field {
            sw=rw; 
            hw=r;
            desc="Machine time. Increments by one every 1000 CPU-cluster cbus clock cycles. A software write takes precedence over an increment in the same cycle.";
        } count[63:0] = 0x0;
    };


    ////////////////////////////////////////////////////////////////////////////
    // Address Map
    ////////////////////////////////////////////////////////////////////////////

    MSIP        MSIP[4]     @0x0;
    MTIMECMP    MTIMECMP[4] @0x4000;
    MTIME       MTIME       @0xbff8;

};

`endif
