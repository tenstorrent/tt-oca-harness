// SPDX-License-Identifier: Apache-2.0
// SPDX-FileCopyrightText: 2026 Tenstorrent USA, Inc.

`ifndef RESET_UNIT_REG_RDL
`define RESET_UNIT_REG_RDL

addrmap reset_unit {
    name = "Reset Unit Address Map";
    desc = "Subsystem reset control, hold and isolation controls, and reset-sequencing status registers.";

    reg SS_CONFIG {
        field {
            sw = rw;
            hw = r;
            desc = "Configuration registers to setup system configuration.
                    Usage is integration-specific; see the adopter chiplet specification.";
        } ss_config[31:0] = 0x0 ;
    };

    reg SS_CONFIG_LOCK {
        field {
            sw = rw;
            hw = r;
            onwrite = woset;
            desc = "SS_CONFIG write lock. Writing 1 to bit i sets it, and SS_CONFIG bit i then ignores
                    writes until the primary reset clears the lock. A write to SS_CONFIG that touches
                    locked bits completes with OKAY: the locked bits keep their value and the unlocked
                    bits of the same write apply.";
        } config_lock[31:0] = 0x0;
    };

    reg SS_FORCE_TO_REF_CLK {
        field {
            sw = rw;
            hw = r;
            desc = "Bit i drives ss_reset_ctrl_o[i].force_to_ref_clk_n unchanged. The reset unit does not use
                    it; its effect and polarity are integration-specific, see the adopter chiplet
                    specification.";
        } force_ss_to_ref_clk_n [31:0] = 0x0;
    };

    reg SS_COLD_RESET_N {
        field {
            sw = rw;
            hw = r;
            desc = "Subsystem active low cold resets";
        } reset_n_n0_scan [31:0] = 0x0;
    };

    reg SS_WARM_RESET_N {
        field {
            sw = rw;
            hw = r;
            desc = "Subsystem active low warm resets";
        } reset_n_n0_scan [31:0] = 0xFFFFFFFF;
    };

    reg SS_CONFIG_HOLD {
        field {
            sw = rw;
            hw = r;
            desc = "Used with warm_reset_n. Asserting ensures all registers configured during boot, including fuse values for
                    export compliance, SRAM repair, other fuse values, etc. are preserved";
        } configuration_state_hold [31:0] = 0x0;
    };

    reg SS_CRITICAL_HOLD {
        field {
            sw = rw;
            hw = r;
            desc = "Used with warm_reset_n. Asserting ensures security, RAS, NMIs, perf counters, debug/trace and other
                    subsystem specific registers are preserved";
        } critical_signal_hold [31:0] = 0x0;
    };

    reg SS_SRAM_HOLD {
        field {
            sw = rw;
            hw = r;
            desc = "Used with warm_reset_n. Asserting ensures SRAMs, latch arrays and anything else that MBIST is
                    used to test and initialize during cold reset are preserved";
        } sram_hold [31:0] = 0x0;
    };

    reg SS_DEBUG_HOLD {
        field {
            sw = rw;
            hw = r;
            desc = "Used with warm_reset_n. Debug hold signal to ensure any debug registers are preserved";
        } debug_hold[31:0] = 0x0;
    };

    reg SS_COLD_RESET_LOCK {
        field {
            sw = rw;
            hw = r;
            onwrite = woset;
            desc = "SS_COLD_RESET_N write lock. Writing 1 to bit i sets it, and SS_COLD_RESET_N bit i then
                    ignores writes until the primary reset clears the lock. A write to SS_COLD_RESET_N
                    that touches locked bits completes with OKAY: the locked bits keep their value and
                    the unlocked bits of the same write apply.";
        } cold_reset_lock[31:0] = 0x0;
    };

    reg SS_RESET_COMPLETE {
        field {
            sw = r;
            hw = w;
            desc = "Response signal from subsystem to indicate reset (or some other critical step) has completed.
                    Each bit reads the synchronized live value of its subsystem's signal; it is not latched.";
        } reset_complete [31:0] = 0x0;
    };

    reg SYNC_REG{
        field {
            sw=rw;
            hw=r;
            desc="Set to assert global sync bit";
        } sync[0:0] = 0x0;
    };

    reg ISOLATE_REQ_REG {
        field {
            sw = rw;
            hw = r;
            desc = "Isolate request. Bit i raises isolate_req_o[i]. The reset unit does not gate any
                    reset with it; a subsystem that must survive a reset gates its own reset with
                    its isolate_req_o bit. Cleared only by the cold reset; survives the cool reset.";
        } isolate_req_reg [31:0] = 0x0;
    };

    reg ISOLATE_REQ_PINEN_REG {
        field {
            sw = rw;
            hw = r;
            desc = "Isolate request pin enable. Bit i lets the isolate request pin raise isolate_req_o[i].
                    The cold reset clears it only while the pin is low; it keeps its value through a
                    cold reset with the pin high, and survives the cool reset.";
        } isolate_req_pinen_reg [31:0] = 0x0;
    };

    reg ISOLATE_REQ_SMC_REG {
        field {
            sw = rw;
            hw = r;
            onwrite = woclr;
            desc = "Isolate request smc. Set by a rising edge of isolate_sequence_trigger_i; software writes 1
                    to clear. A write of 0, or a write whose byte strobes do not select this field,
                    leaves it unchanged; a rising edge in the same cycle as a clearing write wins.
                    Cleared only by the cold reset; survives the cool reset.";
        } isolate_req_smc_reg [0:0] = 0x0;
    };

    reg ISOLATE_REQ_SMCEN_REG {
        field {
            sw = rw;
            hw = r;
            desc = "Isolate request smc enable. Bit i raises isolate_req_o[i] while ISOLATE_REQ_SMC_REG
                    is set, and makes the isolation sequence wait for isolate_req_ack_i[i] before it
                    asserts the cool reset. Cleared only by the cold reset; survives the cool reset.";
        } isolate_req_smcen_reg [31:0] = 0x0;
    };

    enum cool_reset_cause_enum {
        none        = 2'd0 { desc = "No cool reset since the last cold reset"; };
        pin         = 2'd1 { desc = "The cool reset pin"; };
        seq_ack     = 2'd2 { desc = "The isolation sequence, after every subsystem enabled in
                                     ISOLATE_REQ_SMCEN_REG acknowledged its isolation request"; };
        seq_timeout = 2'd3 { desc = "The isolation sequence, when ISOLATE_REQ_FLR_COUNTER_VALUE
                                     expired"; };
    };

    reg ISOLATE_REQ_VIS {
        field {
            sw = r;
            hw = w;
            desc = "Isolate request pin, synchronized to the SMC clock.";
        } isolate_req_pin[0:0] = 0x1;

        field {
            sw = r;
            hw = w;
            encode = cool_reset_cause_enum;
            desc = "Cause of the most recent cool reset: 0 none, 1 pin, 2 seq_ack, 3 seq_timeout.
                    Held through the cool reset and overwritten by the next one; cleared only by
                    the cold reset.";
        } cool_reset_cause[5:4] = 0x0;
    };

    reg ISOLATE_REQ_ACK_CAPTURE {
        field {
            sw = r;
            hw = w;
            desc = "isolate_req_ack_i, captured when the isolation sequence asserts the cool reset.
                    Held through the cool reset and overwritten by the next isolation sequence;
                    cleared only by the cold reset.";
        } isolate_req_ack_capture[31:0] = 0x0;
    };

    reg ISOLATE_REQ_FLR_COUNTER_VALUE {
        field {
            sw = rw;
            hw = r;
            desc = "Isolation sequence timeout N, in reference clock cycles. cool_reset_n asserts N+1
                    cycles after the synchronized isolate_sequence_trigger_i rising edge, or earlier
                    once every subsystem enabled in ISOLATE_REQ_SMCEN_REG acknowledges on
                    isolate_req_ack_i. A trigger edge that arrives before the cool reset hold ends is
                    ignored. Cleared only by the cold reset; survives the cool reset.";
        } isolate_req_flr_counter_value [31:0] = 0x0;
    };

    reg ISOLATE_REQ_FLR_RESET_COUNTER_VALUE {
        field {
            sw = rw;
            hw = r;
            desc = "Isolation sequence hold M: the number of reference clock cycles cool_reset_n stays
                    asserted. A value of 0 prevents the sequence from starting, whatever
                    ISOLATE_REQ_FLR_COUNTER_VALUE holds. Cleared only by the cold reset; survives the
                    cool reset.";
        } isolate_req_flr_reset_counter_value [31:0] = 0x0;
    };


    // --------------------------------------------------

    external SS_CONFIG              SS_CONFIG           @ 0x20;
    SS_CONFIG_LOCK                  SS_CONFIG_LOCK      @ 0x24;

    external SS_COLD_RESET_N        SS_COLD_RESET_N     @ 0x40;
    SS_WARM_RESET_N                 SS_WARM_RESET_N     @ 0x44;

    SS_CONFIG_HOLD                  SS_CONFIG_HOLD      @ 0x48;
    SS_SRAM_HOLD                    SS_SRAM_HOLD        @ 0x4C;
    SS_CRITICAL_HOLD                SS_CRITICAL_HOLD    @ 0x50;
    SS_DEBUG_HOLD                   SS_DEBUG_HOLD       @ 0x54;

    SS_RESET_COMPLETE               SS_RESET_COMPLETE   @ 0x60;

    SS_COLD_RESET_LOCK              SS_COLD_RESET_LOCK  @ 0x70;

    SS_FORCE_TO_REF_CLK             SS_FORCE_TO_REF_CLK @ 0x80;

    SYNC_REG                        SYNC_REG                @ 0xA8;

    external ISOLATE_REQ_REG        ISOLATE_REQ_REG         @ 0xB0;
    external ISOLATE_REQ_PINEN_REG  ISOLATE_REQ_PINEN_REG   @ 0xB4;
    external ISOLATE_REQ_SMC_REG    ISOLATE_REQ_SMC_REG     @ 0xB8;
    external ISOLATE_REQ_SMCEN_REG  ISOLATE_REQ_SMCEN_REG   @ 0xBC;

    ISOLATE_REQ_VIS                 ISOLATE_REQ_VIS         @ 0xC0;

    external ISOLATE_REQ_FLR_COUNTER_VALUE           ISOLATE_REQ_FLR_COUNTER_VALUE           @ 0xC4;
    external ISOLATE_REQ_FLR_RESET_COUNTER_VALUE     ISOLATE_REQ_FLR_RESET_COUNTER_VALUE     @ 0xC8;

    ISOLATE_REQ_ACK_CAPTURE         ISOLATE_REQ_ACK_CAPTURE @ 0xCC;

};

`endif
