// SPDX-License-Identifier: Apache-2.0
// SPDX-FileCopyrightText: 2026 Tenstorrent USA, Inc.

`ifndef RESET_UNIT_REG_RDL
`define RESET_UNIT_REG_RDL

addrmap reset_unit {

    reg SS_CONFIG {
        field {
            sw = rw;
            hw = r;
            desc = "Configuration registers to setup system configuration.
                    Usage is integration-specific; see the adopter chiplet specification.";
        } ss_config[31:0] = 0x0 ;
    };

    reg SS_CONFIG_LOCK {
        field {
            sw = rw;
            hw = r;
            onwrite = woset;
            desc = "Written to lock down SS config. If bit 0 is written, then bit 0 of other SS config
                    cannot be written to again";
        } config_lock[31:0] = 0x0;
    };

    reg SS_FORCE_TO_REF_CLK {
        field {
            sw = rw;
            hw = r;
            desc = "Forces clock to be ref clk. The ensures reset reaches all FFs within a subsystem in same clock cycle";
        } force_ss_to_ref_clk_n [31:0] = 0x0;
    };

    reg SS_COLD_RESET_N {
        field {
            sw = rw;
            hw = r;
            desc = "Subsystem active low cold resets";
        } reset_n_n0_scan [31:0] = 0x0;
    };

    reg SS_WARM_RESET_N {
        field {
            sw = rw;
            hw = r;
            desc = "Subsystem active low warm resets";
        } reset_n_n0_scan [31:0] = 0xFFFFFFFF;
    };

    reg SS_CONFIG_HOLD {
        field {
            sw = rw;
            hw = r;
            desc = "Used with warm_reset_n. Asserting ensures all registers configured during boot, including fuse values for
                    export compliance, SRAM repair, other fuse values, etc. are preserved";
        } configuration_state_hold [31:0] = 0x0;
    };

    reg SS_CRITICAL_HOLD {
        field {
            sw = rw;
            hw = r;
            desc = "Used with warm_reset_n. Asserting ensures security, RAS, NMIs, perf counters, debug/trace and other
                    subsystem specific registers are preserved";
        } critical_signal_hold [31:0] = 0x0;
    };

    reg SS_SRAM_HOLD {
        field {
            sw = rw;
            hw = r;
            desc = "Used with warm_reset_n. Asserting ensures SRAMs, latch arrays and anything else that MBIST is
                    used to test and initialize during cold reset are preserved";
        } sram_hold [31:0] = 0x0;
    };

    reg SS_DEBUG_HOLD {
        field {
            sw = rw;
            hw = r;
            desc = "Used with warm_reset_n. Debug hold signal to ensure any debug registers are preserved";
        } debug_hold[31:0] = 0x0;
    };

    reg SS_COLD_RESET_LOCK {
        field {
            sw = rw;
            hw = r;
            onwrite = woset;
            desc = "Written to lock down SS cold reset. If bit 0 is written, then bit 0 of other SS cold reset
                    cannot be written to again";
        } cold_reset_lock[31:0] = 0x0;
    };

    reg SS_RESET_COMPLETE {
        field {
            sw = r;
            hw = w;
            desc = "Response signal from subsystem to indicate reset (or some other critical step) has completed.
                    Bitwise write 1 to clear";
        } reset_complete [31:0] = 0x0;
    };

    reg SYNC_REG{
        field {
            sw=rw;
            hw=r;
            desc="Set to assert global sync bit";
        } sync[0:0] = 0x0;
    };

    reg ISOLATE_REQ_REG {
        field {
            sw = rw;
            hw = r;
            desc = "Isolate request. This prevents reset from being propagated to SS, keeping them alive in case of a cold reset";
        } isolate_req_reg [31:0] = 0x0;
    };

    reg ISOLATE_REQ_PINEN_REG {
        field {
            sw = rw;
            hw = r;
            desc = "Isolate request pin enable. This enables the external isolate request pin to have an effect on ss isolate requests";
        } isolate_req_pinen_reg [31:0] = 0x0;
    };

    reg ISOLATE_REQ_SMC_REG {
        field {
            sw = rw;
            hw = r;
            desc = "Isolate request smc. Asserted once cfg_flr_pf_active is asserted, de-asserted by sw";
        } isolate_req_smc_reg [0:0] = 0x0;
    };

    reg ISOLATE_REQ_SMCEN_REG {
        field {
            sw = rw;
            hw = r;
            desc = "Isolate request smc enable. This enables the FLR lock to have an effect on ss isolate requests";
        } isolate_req_smcen_reg [31:0] = 0x0;
    };

    reg ISOLATE_REQ_VIS {
        field {
            sw = r;
            hw = w;
            desc = "Visibility bit for isolate request pin";
        } isolate_req_pin[0:0] = 0x1;

        field {
            sw = r;
            hw = w;
            desc = "Visibility bit for cool reset input";
        } cool_reset_n_i[4:4] = 0x1;

        field {
            sw = r;
            hw = w;
            desc = "Visibility bit for cool reset output";
        } cool_reset_n_o[8:8] = 0x1;
    };

    reg ISOLATE_REQ_FLR_COUNTER_VALUE {
        field {
            sw = rw;
            hw = r;
            desc = "Number of cycles post cfg_flr_pf_active assertion is waited until cool_reset_n is asserted";
        } isolate_req_flr_counter_value [31:0] = 0x0;
    };

    reg ISOLATE_REQ_FLR_RESET_COUNTER_VALUE {
        field {
            sw = rw;
            hw = r;
            desc = "Number of cycles cool_reset_n is asserted for. NOTE: The cool reset flow requires this value to be greater than 0; a value of 0 will prevent initiation, regardless of ISOLATE_REQ_FLR_COUNTER_VALUE's value";
        } isolate_req_flr_reset_counter_value [31:0] = 0x0;
    };

    // Strap assignments below mirror the Strap / Strap Notes columns of the GPIO
    // pin table; keep them in sync when a strap moves to a different pad.
    reg STRAPS_LO {
        field {
            sw = r;
            hw = w;
            desc = "Strap value from GPIOs 0 - 31. Bit N holds the value latched on GPIO N.
                    Bits 0 - 10, 16, 17, 24 and 27 - 31 have no strap assigned. Those GPIOs still
                    latch their pad value here, but no strap function consumes it.
                    Strap assignments in this range:
                    * bit 11: CHIP_ID[3] - CHIP_ID is the I2C/I3C static address strap
                    * bit 12: CHIP_ID[2] - CHIP_ID is the I2C/I3C static address strap
                    * bit 13: BYPASS_SRAM_REPAIR - Bypass the memory repair process
                    * bit 14: TEST_EN - Enable DFT test mode
                    * bit 15: CHIP_ID[1] - CHIP_ID is the I2C/I3C static address strap
                    * bit 18: BOOT_I2C - Default alternate boot channel is I3C0 and can be reconfigured to use I2C0
                    * bit 19: BOOT_RECOVERY - Use I3C0 for BL1 boot image loading instead of the SPI channel
                    * bit 20: BL0_PLLCLK - Use the PLL generated clock by default in BL0, and override to use the reference clock when this strap is asserted
                    * bit 21: STATUS_RPT_DISABLE - Disable BL0 status reporting. It is on by default
                    * bit 22: SPI_USE_FUSED_CONFIG - Use the SPI configuration values stored in the fuse field
                    * bit 23: CHIP_ID[0] - CHIP_ID is the I2C/I3C static address strap
                    * bit 25: PRIMARY_CHIPLET - The primary chiplet has this strap bonded out to identify it as the boot master
                    * bit 26: SRAM_AUTO_ZERO_DISABLE - Disable auto zero of the SMC SRAM when asserted";
        } straps[31:0] = 0x0;
    };

    // Width is smc_pkg::NUM_BONDED_GPIO-32 (61-32 = 29). RDL cannot import smc_pkg,
    // so this must be updated by hand if the bonded GPIO count changes.
    reg STRAPS_HI {
        field {
            sw = r;
            hw = w;
            desc = "Strap value from GPIOs 32 - 60. Bit N holds the value latched on GPIO N+32.
                    All bits other than those listed below have no strap assigned. Those GPIOs
                    still latch their pad value here, but no strap function consumes it.
                    GPIOs 61 - 64 cannot be strapped: they are unbonded (not packaged out) and lie
                    outside this register, which ends at GPIO 60 (smc_pkg::NUM_BONDED_GPIO-1).
                    Strap assignments in this range:
                    * bit 22 (GPIO 54): MBIST_BYPASS - Ignore results of Power-On MBIST for boot
                    * bit 26 (GPIO 58): ROTATE_UPDATE - Swaps primary and backup image in SEP BL0 ROM";
        } straps[28:0] = 0x0;
    };

    // --------------------------------------------------

    external SS_CONFIG              SS_CONFIG           @ 0x20;
    SS_CONFIG_LOCK                  SS_CONFIG_LOCK      @ 0x24;

    external SS_COLD_RESET_N        SS_COLD_RESET_N     @ 0x40;
    SS_WARM_RESET_N                 SS_WARM_RESET_N     @ 0x44;

    SS_CONFIG_HOLD                  SS_CONFIG_HOLD      @ 0x48;
    SS_SRAM_HOLD                    SS_SRAM_HOLD        @ 0x4C;
    SS_CRITICAL_HOLD                SS_CRITICAL_HOLD    @ 0x50;
    SS_DEBUG_HOLD                   SS_DEBUG_HOLD       @ 0x54;

    SS_RESET_COMPLETE               SS_RESET_COMPLETE   @ 0x60;

    SS_COLD_RESET_LOCK              SS_COLD_RESET_LOCK  @ 0x70;

    SS_FORCE_TO_REF_CLK             SS_FORCE_TO_REF_CLK @ 0x80;

    STRAPS_LO                       STRAPS_LO               @ 0x90;
    STRAPS_HI                       STRAPS_HI               @ 0x94;

    SYNC_REG                        SYNC_REG                @ 0xA8;

    external ISOLATE_REQ_REG        ISOLATE_REQ_REG         @ 0xB0;
    external ISOLATE_REQ_PINEN_REG  ISOLATE_REQ_PINEN_REG   @ 0xB4;
    external ISOLATE_REQ_SMC_REG    ISOLATE_REQ_SMC_REG     @ 0xB8;
    external ISOLATE_REQ_SMCEN_REG  ISOLATE_REQ_SMCEN_REG   @ 0xBC;

    ISOLATE_REQ_VIS                 ISOLATE_REQ_VIS         @ 0xC0;

    external ISOLATE_REQ_FLR_COUNTER_VALUE           ISOLATE_REQ_FLR_COUNTER_VALUE           @ 0xC4;
    external ISOLATE_REQ_FLR_RESET_COUNTER_VALUE     ISOLATE_REQ_FLR_RESET_COUNTER_VALUE     @ 0xC8;

};

`endif
