// SPDX-License-Identifier: Apache-2.0
// SPDX-FileCopyrightText: 2026 Tenstorrent USA, Inc.

`ifndef CHIP_CONFIG_REG_RDL
`define CHIP_CONFIG_REG_RDL

addrmap chip_config {
    name = "Chip Configuration Address Map";
    desc = "Chip version, identification, and lifecycle-state registers.";

	reg VERSION_LO {
        field {
            sw = r;
            hw = w;
            desc = "SMC version, lower 32 bits";
        } version_lo [31:0] = 0x000100A0;
    };

    reg VERSION_HI {
        field {
            sw = r;
            hw = w;
            desc = "SMC version, upper 32 bits";
        } version_hi [31:0] = 0x0;
    };

    reg CHIP_ID {
        field {
            sw = r;
            hw = w;
            desc = "Chip ID, a constant fixed when the SMC is integrated, not read from fuses (e.g. 0 = Memory, 1 = CPU, 2 = AI Compute, 3 = Ethernet). The register has no storage: a read returns that constant, and the reset value is the default constant.";
        } chip_id [31:0] = 0x0;
    };

    reg LC_STATE {
        field {
            sw = r;
            hw = w;
            desc = "Lifecycle state from SEP, differentially encoded: {~raw[3:0], raw[3:0]}. The register has no storage: each read returns the value SEP drives at that moment, neither latched nor decoded. The reset value 0x0F is the INVALID encoding 4'b1111, the fail-safe state, and is what SEP itself drives until fuse sensing completes. An SMU built without SEP drives 0xF0 (TEST_DEV).";
        } lc_state[7:0] = 0x0f;
    };

	// --------------------------------------------------

	VERSION_LO                      VERSION_LO          @ 0x00;
	VERSION_HI                      VERSION_HI          @ 0x04;
	CHIP_ID                         CHIP_ID             @ 0x08;
	LC_STATE                        LC_STATE            @ 0x0C;

};

`endif
