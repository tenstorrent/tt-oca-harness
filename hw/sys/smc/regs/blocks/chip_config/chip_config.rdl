// SPDX-License-Identifier: Apache-2.0
// SPDX-FileCopyrightText: 2026 Tenstorrent USA, Inc.

`ifndef CHIP_CONFIG_REG_RDL
`define CHIP_CONFIG_REG_RDL

addrmap chip_config {
    name = "Chip Configuration Address Map";
    desc = "Chip version, chiplet type, and lifecycle-state registers.";

	reg VERSION_LO {
        field {
            sw = r;
            hw = w;
            desc = "SMC version identifier, lower 32 bits, set by eight metal-programmable revision cells, one byte per cell, so a metal-only respin can change it. The register has no storage: a read returns the cell values, and the reset value is the version the cells are tied to.";
        } version_lo [31:0] = 0x000100A0;
    };

    reg VERSION_HI {
        field {
            sw = r;
            hw = w;
            desc = "SMC version identifier, upper 32 bits, set by eight metal-programmable revision cells, one byte per cell, so a metal-only respin can change it. The register has no storage: a read returns the cell values, and the reset value is the version the cells are tied to.";
        } version_hi [31:0] = 0x0;
    };

    enum chiplet_type_e {
        MEMORY     = 32'd0 { desc = "Memory chiplet"; };
        CPU        = 32'd1 { desc = "CPU chiplet"; };
        AI_COMPUTE = 32'd2 { desc = "AI compute chiplet"; };
        ETHERNET   = 32'd3 { desc = "Ethernet chiplet"; };
    };

    reg CHIPLET_TYPE {
        field {
            sw = r;
            hw = w;
            encode = chiplet_type_e;
            desc = "Kind of chiplet the SMC is integrated in, a constant fixed when the SMC is integrated, not read from fuses: 0 = MEMORY, 1 = CPU, 2 = AI_COMPUTE, 3 = ETHERNET; values 4 and above are reserved. Bits 1:0 are the upper two bits of the boot ROM's fallback I2C and I3C address, so two chiplet types that share a bus must report different values. The register has no storage: a read returns that constant, and the reset value is the default constant.";
        } chiplet_type [31:0] = 0x0;
    };

    reg LC_STATE {
        field {
            sw = r;
            hw = w;
            desc = "Lifecycle state from SEP, differentially encoded: {~raw[3:0], raw[3:0]}. The register has no storage: each read returns the value SEP drives at that moment, neither latched nor decoded. The reset value 0x0F is the INVALID encoding 4'b1111, the fail-safe state, and is what SEP itself drives until fuse sensing completes. An SMU built without SEP drives 0xF0 (TEST_DEV).";
        } lc_state[7:0] = 0x0f;
    };

	// --------------------------------------------------

	VERSION_LO                      VERSION_LO          @ 0x00;
	VERSION_HI                      VERSION_HI          @ 0x04;
	CHIPLET_TYPE                    CHIPLET_TYPE        @ 0x08;
	LC_STATE                        LC_STATE            @ 0x0C;

};

`endif
