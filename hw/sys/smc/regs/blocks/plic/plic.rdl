// SPDX-License-Identifier: Apache-2.0
// SPDX-FileCopyrightText: 2026 Tenstorrent USA, Inc.

`ifndef PLIC_REG_RDL
`define PLIC_REG_RDL

addrmap plic {
    name = "PLIC Address Map";
    desc = "Platform-Level Interrupt Controller register interface.";
    
    ////////////////////////////////////////////////////////////////////////////
    // Register Definitions
    ////////////////////////////////////////////////////////////////////////////

    reg PRIORITY {
        field {
            sw=rw;
            hw=r;
            desc="Priority of interrupt. The higher the set value, the higher the priority.
                  For interrupts with the same priority, the tie is broken by interrupt ID; interrupts with the lowest ID has highest effective priority.
                  Interrupts start counting at 1.";
        } value[2:0];
    };

    reg PENDING {
        field {
            sw=r;
            hw=rw;
            desc="Set to 1 if interrupt source 1 is pending, regardless of its enable or priority setting.
                  Interrupts start counting at 1.";
        } value[31:0] = 0x0;
    };

    reg ENABLE {
        field {
            sw=rw;
            hw=r;
            desc="Set bits to 1 if interrupt should be enabled.
                  Interrupts start counting at 1.";
        } value[31:0];
    };

    reg THRESHOLD {
        field {
            sw=rw;
            hw=r;
            desc="Interrupt & claim threshold. Maximum value is 7.
                  Any interrupt with a priority less than the threshold cannot interrupt the cpu";
        } value[2:0];
    };

    reg CLAIM_COMPLETE {
        field {
            sw=rw;
            hw=r;
            desc="Claim/Complete register.
                  Reading this register returns the claimed interrupt number and makes it no longer pending.
                  Writing the interrupt number back completes the interrupt.";
        } value[31:0];
    };

    ////////////////////////////////////////////////////////////////////////////
    // Address Map
    ////////////////////////////////////////////////////////////////////////////

    PRIORITY        PRIORITY[337]               @0x0;

    PENDING         PENDING[11]                 @0x1000;

    ENABLE          CORE0_MEIP_ENABLE[11]       @0x2000;
    ENABLE          CORE1_MEIP_ENABLE[11]       @0x2080;
    ENABLE          CORE2_MEIP_ENABLE[11]       @0x2100;
    ENABLE          CORE3_MEIP_ENABLE[11]       @0x2180;

    ENABLE          CORE0_SEIP_ENABLE[11]       @0x2200;
    ENABLE          CORE1_SEIP_ENABLE[11]       @0x2280;
    ENABLE          CORE2_SEIP_ENABLE[11]       @0x2300;
    ENABLE          CORE3_SEIP_ENABLE[11]       @0x2380;

    THRESHOLD       CORE0_MEIP_THRESHOLD        @0x200000;
    CLAIM_COMPLETE  CORE0_MEIP_CLAIM_COMPLETE   @0x200004;

    THRESHOLD       CORE1_MEIP_THRESHOLD        @0x201000;
    CLAIM_COMPLETE  CORE1_MEIP_CLAIM_COMPLETE   @0x201004;
    
    THRESHOLD       CORE2_MEIP_THRESHOLD        @0x202000;
    CLAIM_COMPLETE  CORE2_MEIP_CLAIM_COMPLETE   @0x202004;

    THRESHOLD       CORE3_MEIP_THRESHOLD        @0x203000;
    CLAIM_COMPLETE  CORE3_MEIP_CLAIM_COMPLETE   @0x203004;

    THRESHOLD       CORE0_SEIP_THRESHOLD        @0x204000;
    CLAIM_COMPLETE  CORE0_SEIP_CLAIM_COMPLETE   @0x204004;

    THRESHOLD       CORE1_SEIP_THRESHOLD        @0x205000;
    CLAIM_COMPLETE  CORE1_SEIP_CLAIM_COMPLETE   @0x205004;

    THRESHOLD       CORE2_SEIP_THRESHOLD        @0x206000;
    CLAIM_COMPLETE  CORE2_SEIP_CLAIM_COMPLETE   @0x206004;

    THRESHOLD       CORE3_SEIP_THRESHOLD        @0x207000;
    CLAIM_COMPLETE  CORE3_SEIP_CLAIM_COMPLETE   @0x207004;
};

`endif
