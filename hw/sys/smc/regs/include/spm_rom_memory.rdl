// SPDX-License-Identifier: Apache-2.0
// SPDX-FileCopyrightText: 2026 Tenstorrent USA, Inc.

`ifndef SPM_ROM_MEMORY_RDL
`define SPM_ROM_MEMORY_RDL

// This RDL defines an address space for the ROM

mem spm_rom_memory #(
    longint unsigned NUM_ENTRIES = 16384,
    longint unsigned WIDTH       = 64
) {
    desc = "Scratchpad ROM memory, present only in non-CPL configurations.";

    mementries = NUM_ENTRIES;
    memwidth   = WIDTH;

    // a single word of the memory
    reg mem_word {
        regwidth = 64;
        field {
           sw=rw;
           hw=rw;
        } data[WIDTH-1:0];
    };

    // the entire memory is an array of memory words
    mem_word mem_array[NUM_ENTRIES];

`ifdef OCAH_DOC_MEMORY_MAP
    ocah_hole_note = "A write answers SLVERR and leaves the ROM unchanged.";
`endif
};

`endif


