// SPDX-License-Identifier: Apache-2.0
// SPDX-FileCopyrightText: 2026 Tenstorrent USA, Inc.

`ifndef EXT_MEMORY_RDL
`define EXT_MEMORY_RDL

mem ext_memory #(
    longint unsigned NUM_ENTRIES = 1024,
    longint unsigned WIDTH       = 32
) {
    desc = "External Memory";

    mementries = NUM_ENTRIES;
    memwidth   = WIDTH;

    // a single word of the memory
    reg mem_word {
        regwidth = 32;
        field {
           sw=rw;
           hw=rw;
        } data[WIDTH-1:0];
    };

    // the entire memory is an array of memory words
    mem_word mem_array[NUM_ENTRIES];

};

`endif


