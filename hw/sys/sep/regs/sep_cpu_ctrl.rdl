`ifndef SEP_CPU_CTRL_RDL_DEFINED
`define SEP_CPU_CTRL_RDL_DEFINED
addrmap sep_cpu_ctrl {

    reg REFERENCE_COUNTER {
        regwidth = 64;
        accesswidth = 64;
        field  {
            sw=r;
            hw=w;
            desc="SEP REFERENCE COUNTER, counting after deassert of cold reset";
        } rc [63:0];
    };

    reg CLOCK_GATE_CTRL {
        regwidth = 64;
        accesswidth = 64;
        field  {
            sw=rw;
            hw=r;
            desc="Clockgate enable for the SPAcc/ Default is 1, this is using a static clkgater, meaning out clock is enabled by default";
        } spacc_cg_enable [0:0] = 0x1;

        field  {
            sw=rw;
            hw=r;
            desc="Clockgate enable for the PKA, default should be 1, using clkgater, meaining out clock is enabled";
        } pka_cg_enable [1:1] = 0x1;

        field  {
            sw=rw;
            hw=r;
            desc="Clockgate enable for the DMA, using clk_gater, deafault should be 0";
        } dma_cg_enable [2:2] = 0x0;

        field  {
            sw=rw;
            hw=r;
            desc="Clockgate enable for the mailbox,using clk_gater, default should be 0";
        } mailbox_cg_en [3:3] = 0x0;

        field  {
            sw=rw;
            hw=r;
            desc="Clockgate enable for the fabric";
        } fabric_cg_enable [4:4] = 0x0;


        field  {
            sw=rw;
            hw=r;
            desc="Clockgate enable for the inbound filters, using clk_gater, default should be 0";
        } filter_in_cg_enable [6:6] = 0x0;

        field  {
            sw=rw;
            hw=r;
            desc="Clockgate enable for the sram, using clkgater, default should be 1";
        } sram_cg_enable [7:7] = 0x1;

        field  {
            sw=rw;
            hw=r;
            desc="Clockgate enable for the zeroer, using clkgater, but this enable has been inverted, so shouould use 0 as default";
        } zeroer_cg_enable [8:8] = 0x0;

        field  {
            sw=rw;
            hw=r;
            desc="Clockgate enable for the alias remap, using clk_gater, default should be 0";
        } alias_remap_cg_enable [9:9] = 0x0;

        field  {
            sw=rw;
            hw=r;
            desc="Clockgate enable for the outbound filters, even using clkgater, but this enable has been inverted, so should use 0 as default";
        } filter_out_cg_enable [10:10] = 0x0;

        field  {
            sw=rw;
            hw=r;
            desc="Clockgate enable for the opentitan hmac engine/ default is 0, out clock is always enabled";
        } ot_hmac_cg_enable [11:11] = 0x0;

        field  {
            sw=rw;
            hw=r;
            desc="Clockgate enable for the entropy fifo, using clk_gater, default should be 0";
        } entropy_fifo_cg_enable [12:12] = 0x0;

        field {
            sw=rw;
            hw=r;
            desc="Clockgate hysteresis";
        } cg_hysteresis [21:16] = 0x1f;
    };

   reg TIMEOUT_INTERRUPT {
       regwidth = 64;
       accesswidth = 64;

       desc = "Timeout interrupt";

       field  {
            sw=r;
            hw=w;
            desc="Timeout interrupt for troot axi";
        } troot_timeout_int [0:0] = 0x0;

        field  {
            sw=r;
            hw=w;
            desc="Timeout interrupt for sys in axi";
        } sys_in_timeout_int [1:1] = 0x0;

        field  {
            sw=r;
            hw=w;
            desc="Timeout interrupt for spacc axi";
        } spacc_timeout_int [2:2] = 0x0;

        field  {
            sw=r;
            hw=w;
            desc="Timeout interrupt for dma data axi";
        } dma_data_timeout_int [3:3] = 0x0;

        field  {
            sw=r;
            hw=w;
            desc="Timeout interrupt for dma data axi";
        } alias_remap_timeout_int [4:4] = 0x0;

        field  {
            sw=r;
            hw=w;
            desc="Timeout interrupt for dma data axi";
        } filter_out_timeout_int [5:5] = 0x0;

        field  {
            sw=r;
            hw=w;
            desc="Timeout interrupt for entropy fifo read axil";
        } entropy_read_timeout_int [6:6] = 0x0;

        field  {
            sw=r;
            hw=w;
            desc="Timeout interrupt for entropy fifo write axil";
        } entropy_write_timeout_int [7:7] = 0x0;

        field  {
            sw=r;
            hw=w;
            desc="Timeout interrupt for entropy fifo inbound mailbox";
        } inbound_mailbox_timeout_int [8:8] = 0x0;

        field  {
            sw=r;
            hw=w;
            desc="Timeout interrupt for entropy fifo outbound mailbox";
        } outbound_mailbox_timeout_int [9:9] = 0x0;
   };

    reg PKA_CTRL {
        field {
            sw=rw;
            hw=r;
            desc="pka_dpa_disable";
        } pka_dpa_disable[0:0] = 0x1;
        field {
            sw=rw;
            hw=r;
            desc="pka_noise_src";
        } pka_noise_src[8:8] = 0x0;
        field {
            sw=rw;
            hw=r;
            desc="pka_noise_src_valid";
        } pka_noise_src_valid[16:16] = 0x0;
    };

    reg SPACC_CTRL {
        field {
            sw=rw;
            hw=r;
            desc="spacc_dpa_disable";
        } spacc_dpa_disable[0:0] = 0x1;
        field {
            sw=rw;
            hw=r;
            desc="spacc_dpa_rand";
        } spacc_dpa_rand[8:8] = 0x0;
        field {
            sw=rw;
            hw=r;
            desc="spacc_dpa_rand_vld";
        } spacc_dpa_rand_vld[16:16] = 0x0;
    };

    reg TIMEOUT_COUNT {
        regwidth = 64;
        accesswidth = 64;

        field  {
            sw=rw;
            hw=r;
            desc="Timeout value";
        } data [47:0] = 0x0;
    };

    reg TIMEOUT_ENABLE {
        regwidth = 64;
        accesswidth = 64;

        field  {
            sw=rw;
            hw=r;
            desc="Timeout enable for troot axi";
        } troot_timeout_en [0:0] = 0x0;

        field  {
            sw=rw;
            hw=r;
            desc="Timeout enable for sys in axi";
        } sys_in_timeout_en [1:1] = 0x0;

        field  {
            sw=rw;
            hw=r;
            desc="Timeout enable for spacc axi";
        } spacc_timeout_en [2:2] = 0x0;

        field  {
            sw=rw;
            hw=r;
            desc="Timeout enable for dma data axi";
        } dma_data_timeout_en [3:3] = 0x0;

        field  {
            sw=rw;
            hw=r;
            desc="Timeout enable for input alias remap";
        } alias_remap_timeout_en [4:4] = 0x0;

        field  {
            sw=rw;
            hw=r;
            desc="Timeout enable for output filter";
        } filter_out_timeout_en [5:5] = 0x0;

        field  {
            sw=rw;
            hw=r;
            desc="Timeout enable for entropy read";
        } entropy_read_timeout_en [6:6] = 0x0;

        field  {
            sw=rw;
            hw=r;
            desc="Timeout enable for entropy write";
        } entropy_write_timeout_en [7:7] = 0x0;

         field  {
            sw=rw;
            hw=r;
            desc="Timeout enable for inbound mailbox";
        } inbound_mailbox_timeout_en [8:8] = 0x0;

         field  {
            sw=rw;
            hw=r;
            desc="Timeout enable for outbound mailbox";
        } outbound_mailbox_timeout_en [9:9] = 0x0;
    };

    reg TIMEOUT_CLEAR {
        regwidth = 64;
        accesswidth = 64;

        field  {
            sw=w;
            hw=r;
            singlepulse=true;
            desc="Timeout interrupt clear for troot axi";
        } troot_timeout_clear [0:0] = 0x0;

        field  {
            sw=w;
            hw=r;
            singlepulse=true;
            desc="Timeout interrupt clear for sys in axi";
        } sys_in_timeout_clear [1:1] = 0x0;

        field  {
            sw=w;
            hw=r;
            singlepulse=true;
            desc="Timeout interrupt clear for spacc axi";
        } spacc_timeout_clear [2:2] = 0x0;

        field  {
            sw=w;
            hw=r;
            singlepulse=true;
            desc="Timeout interrupt clear for dma data axi";
        } dma_data_timeout_clear [3:3] = 0x0;


        field  {
            sw=w;
            hw=r;
            singlepulse=true;
            desc="Timeout interrupt clear for input alias remap";
        } alias_remap_timeout_clear [4:4] = 0x0;

        field  {
            sw=w;
            hw=r;
            singlepulse=true;
            desc="Timeout interrupt clear for output filter";
        } filter_out_timeout_clear [5:5] = 0x0;

        field  {
            sw=w;
            hw=r;
            singlepulse=true;
            desc="Timeout interrupt clear for entropy read";
        } entropy_read_timeout_clear [6:6] = 0x0;

        field  {
            sw=w;
            hw=r;
            singlepulse=true;
            desc="Timeout interrupt clear for entropy write";
        } entropy_write_timeout_clear [7:7] = 0x0;

         field  {
            sw=w;
            hw=r;
            singlepulse=true;
            desc="Timeout interrupt clear for inbound mailbox";
        } inbound_mailbox_timeout_clear [8:8] = 0x0;

        field  {
            sw=w;
            hw=r;
            singlepulse=true;
            desc="Timeout interrupt clear for outbound mailbox";
        } outbound_mailbox_timeout_clear [9:9] = 0x0;
    };

    reg TIMEOUT_MODE {
        regwidth = 64;
        accesswidth = 64;

        field  {
            sw=w;
            hw=r;
            desc="Timeout mode for troot axi";
        } troot_timeout_mode [1:0] = 0x0;

        field  {
            sw=w;
            hw=r;
            desc="Timeout mode for sys in axi";
        } sys_in_timeout_mode [3:2] = 0x0;

        field  {
            sw=w;
            hw=r;
            desc="Timeout mode for spacc axi";
        } spacc_timeout_mode [5:4] = 0x0;

        field  {
            sw=w;
            hw=r;
            desc="Timeout mode for dma data axi";
        } dma_data_timeout_mode [7:6] = 0x0;


        field  {
            sw=w;
            hw=r;
            desc="Timeout mode for input alias remap";
        } alias_remap_timeout_mode [9:8] = 0x0;

        field  {
            sw=w;
            hw=r;
            desc="Timeout mode for output filter";
        } filter_out_timeout_mode [11:10] = 0x0;

        field  {
            sw=w;
            hw=r;
            desc="Timeout mode for entropy read";
        } entropy_read_timeout_mode [13:12] = 0x0;

        field  {
            sw=w;
            hw=r;
            desc="Timeout mode for entropy write";
        } entropy_write_timeout_mode [15:14] = 0x0;

        field  {
            sw=w;
            hw=r;
            desc="Timeout mode for inbound mailbox";
        } inbound_mailbox_timeout_mode [17:16] = 0x0;

        field  {
            sw=w;
            hw=r;
            desc="Timeout mode for outbound mailbox";
        } outbound_mailbox_timeout_mode [19:18] = 0x0;
    };

    reg SEP_VERSION_ID {
        regwidth = 64;
        accesswidth = 64;
        field  {
            sw=r;
            hw=na;
            desc="Version ID for the CPU";
        } version_id [31:0] = 0xdeadbeef;
    };

    reg SEP_TEST_CTRL {
        regwidth = 32;
        accesswidth = 32;
        field  {
            sw=r;
            hw=w;
            desc="Fast SPI Enable";
        } fast_spi_en [31:31] = 0x0;

        field  {
            sw=r;
            hw=w;
            desc="Fast ICCM Enable";
        } fast_iccm_en [30:30] = 0x0;

        field  {
            sw=r;
            hw=w;
            desc="Fast DCCM Enable";
        } fast_dccm_en [29:29] = 0x0;

        field  {
            sw=r;
            hw=w;
            desc="Fast SRAM Enable";
        } fast_sram_en [28:28] = 0x0;

        field  {
            sw=r;
            hw=w;
            desc="Fast PKA Enable";
        } fast_pka_en [27:27] = 0x0;

        field  {
            sw=r;
            hw=w;
            desc="Fast SPAcc Enable";
        } fast_spacc_en [26:26] = 0x0;

        field  {
            sw=r;
            hw=w;
            desc="SEP is standalone (not part of eg SMU)";
        } sep_standalone [25:25] = 0x0;
    };

    reg SEP_GLOBAL_BASE_ADDR {
        regwidth = 64;
        accesswidth = 64;
        field {
            sw = rw;
            hw = r;
        } addr[55:0] = 0x0;
    };

    reg SEP_LOCAL_BASE_ADDR {
        regwidth = 64;
        accesswidth = 64;
        field {
            sw = rw;
            hw = r;
        } addr[55:0] = 0xC0000000; // TODO: Update once spec is defined
    };

    reg SEP_REGION_SIZE {
        regwidth = 64;
        accesswidth = 64;
        field {
            sw = rw;
            hw = r;
        } size[31:0] = 0x01000000; // 16 MiB (FW reprograms per chiplet spec)
    };

	reg SMU_GLOBAL_BASE_ADDR {
        regwidth = 64;
        accesswidth = 64;
        field {
            sw = rw;
            hw = r;
        } addr[55:0] = 0x80000000; // TODO: Update once spec is defined
    };

    reg SMU_REGION_SIZE {
        regwidth = 64;
        accesswidth = 64;
        field {
            sw = rw;
            hw = r;
        } size[31:0] = 0x40000000; // TODO: Update once spec is defined
    };

    reg SMC_FUSE_SENSE_STATUS {
        regwidth = 64;
        accesswidth = 64;

        field {
            sw = r;
            hw = w;
            desc = "This bit indicates when SMC's fuse sense is completed. While fuse sense if ongoing, SMC fabric will be in reset. Any requests to the SMC will hang.
                    When this is 1, it is safe to send requests to the SMC.";
        } smc_fuse_sense_done[0:0] = 0x0;
    };

    reg SEP_FUSE_SENSE_STATUS {
        regwidth = 64;
        accesswidth = 64;

        field {
            sw = r;
            hw = w;
            desc = "This reg is used to indicate the fuse sense status of SEP. ";
        } sep_fuse_sense_done[0:0] = 0x0;
    };

    reg SEP_STRAPS {
        field {
            sw = r;
            hw = w;
            desc="straps for test_en -> Used to be latched by SEP and generate the secure_tm ";
        } test_en[0:0] = 0x0;

        field {
            sw = r;
            hw = w;
            desc="straps for bypass_mem_repair -> Used to indicate if the memory repair should be bypassed";
        } bypass_mem_repair[1:1] = 0x0;

    };

    reg RAS_BANK_INFO {
        field {
            sw = rw;
            hw = r;
            desc = "Chiplet type ID";
        } bank_chip [3:0] = 0x0;

        field {
            sw = rw;
            hw = r;
            desc = "Chiplet instance ID";
        } bank_instance [7:4] = 0x0;
    };

    reg SEP_SW_DEBUG {
        regwidth = 64;
        accesswidth = 64;

        field {
            sw = rw;
            hw = r;
            desc = "software writtable debug information. This reg is routed to CLA";
        } sep_sw_debug[31:0] = 0x0;
    };

    reg SEP_NMI_VEC {
        regwidth = 64;
        accesswidth = 64;
        desc = "NMI vector address for VeeR-EL2 CPU. The default value is 0xC000_1000. The NMI
                interrupt is used for the WDT Bark interrupt.";

        field {
            sw = rw;
            hw = r;
            desc = "NMI vector address [31:1] for VeeR-EL2 CPU. Bit 0 is always 0 (aligned).
                    Address where CPU jumps on Non-Maskable Interrupt. This is used for the
                    WDT Bark interrupt.";
        } nmi_vec[31:1] = 0x6000_0080;

        field {
            sw = r;
            hw = r;
            desc = "Reserved, bit 0 is always 0 (aligned)";
        } rsvd[0:0] = 0x0;
    };

    reg SEP_NMI_VEC_LOCK {
        regwidth = 64;
        accesswidth = 64;
        desc = "Lock the NMI vector address. Once locked, the NMI vector address cannot be changed. The
                NMI interrupt is used for the WDT Bark interrupt.";

        field {
            sw = rw;
            hw = r;
            woset;
            desc = "Lock the NMI vector address. Once locked, the NMI vector address cannot be changed.
                    The NMI interrupt is used for the WDT Bark interrupt.";
        } lock[0:0] = 0x0;
    };

    reg EXT_TRNG_SRC_SEL {
        regwidth = 64;
        accesswidth = 64;
        desc = "Per-stream external TRNG source selection for crypto subsystem entropy muxes.";

        field {
            sw = rw;
            hw = r;
            desc = "TRNG source select per stream. Bit N selects the source for stream N.
                    0 = internal DRBG output, 1 = external TRNG (default).";
        } sel[1:0] = 0x3;
    };

    reg EXT_TRNG_SRC_SEL_LOCK {
        regwidth = 64;
        accesswidth = 64;
        desc = "Lock the TRNG source selection. Once locked, EXT_TRNG_SRC_SEL cannot be changed until reset.";

        field {
            sw = rw;
            hw = r;
            woset;
            desc = "Lock TRNG source selection. Once set, cannot be cleared by software.";
        } lock[0:0] = 0x0;
    };

    // ----------------------------------------------

    // Core Specific Address Space 0x0 - 0x0ffff
    CLOCK_GATE_CTRL       CLOCK_GATE_CTRL                         @ 0x8;
    REFERENCE_COUNTER     REFERENCE_COUNTER                       @ 0x10;
    TIMEOUT_INTERRUPT     TIMEOUT_INTERRUPT                       @ 0x18;

    PKA_CTRL              PKA_CTRL                                @ 0x20;
    SPACC_CTRL            SPACC_CTRL                              @ 0x30;

    TIMEOUT_COUNT         TIMEOUT_COUNT_TROOT                     @ 0x40;
    TIMEOUT_COUNT         TIMEOUT_COUNT_DMA                       @ 0x48;
    TIMEOUT_COUNT         TIMEOUT_COUNT_SPACC                     @ 0x50;
    TIMEOUT_COUNT         TIMEOUT_COUNT_SYS_IN                    @ 0x58;
    TIMEOUT_COUNT         TIMEOUT_COUNT_MAILBOX_INBOUND           @ 0x60;
    TIMEOUT_COUNT         TIMEOUT_COUNT_MAILBOX_OUTBOUND          @ 0x68;
    TIMEOUT_COUNT         TIMEOUT_COUNT_ENTROPY_WRITE             @ 0x70;
    TIMEOUT_COUNT         TIMEOUT_COUNT_ENTROPY_READ              @ 0x78;
    TIMEOUT_COUNT         TIMEOUT_COUNT_FILTER_OUT                @ 0x80;
    TIMEOUT_COUNT         TIMEOUT_COUNT_ALIAS_REMAP               @ 0x88;
    TIMEOUT_ENABLE        TIMEOUT_ENABLE                          @ 0x90;
    TIMEOUT_CLEAR         TIMEOUT_CLEAR                           @ 0x98;
    TIMEOUT_MODE          TIMEOUT_MODE                            @ 0xA0;

    SEP_TEST_CTRL         SEP_TEST_CTRL                           @ 0xb0;

    SEP_GLOBAL_BASE_ADDR  SEP_GLOBAL_BASE_ADDR                    @ 0xc0;
    SEP_LOCAL_BASE_ADDR   SEP_LOCAL_BASE_ADDR                     @ 0xc8;
    SEP_REGION_SIZE       SEP_REGION_SIZE                         @ 0xd0;

	SMU_GLOBAL_BASE_ADDR  SMU_GLOBAL_BASE_ADDR                    @ 0x100;
    SMU_REGION_SIZE       SMU_REGION_SIZE                         @ 0x110;

    SMC_FUSE_SENSE_STATUS SMC_FUSE_SENSE_STATUS                  @ 0x140;
    SEP_FUSE_SENSE_STATUS SEP_FUSE_SENSE_STATUS                  @ 0x150;

    SEP_STRAPS            SEP_STRAPS                              @ 0x160;

    RAS_BANK_INFO         RAS_BANK_INFO                           @ 0x170;
    SEP_SW_DEBUG          SEP_SW_DEBUG                            @ 0x178;

    SEP_NMI_VEC           SEP_NMI_VEC                             @ 0x180;
    SEP_NMI_VEC_LOCK      SEP_NMI_VEC_LOCK                        @ 0x188;

    EXT_TRNG_SRC_SEL      EXT_TRNG_SRC_SEL                        @ 0x190;
    EXT_TRNG_SRC_SEL_LOCK EXT_TRNG_SRC_SEL_LOCK                   @ 0x198;

    // Generic Address Space 0x1000 - 0x1fff
    SEP_VERSION_ID        SEP_VERSION_ID                          @ 0x1000;

    //----------------------------------------------

    // Constraints
    SEP_NMI_VEC.nmi_vec->swwel = SEP_NMI_VEC_LOCK.lock;
    EXT_TRNG_SRC_SEL.sel->swwel = EXT_TRNG_SRC_SEL_LOCK.lock;
};

`endif
