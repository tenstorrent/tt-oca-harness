// SPDX-License-Identifier: Apache-2.0
// SPDX-FileCopyrightText: 2026 Tenstorrent USA, Inc.

`ifndef SEP_SRAM_RDL
`define SEP_SRAM_RDL

// This RDL defines an address space for the SRAM

mem sep_sram #(
    longint unsigned NUM_ENTRIES = 0x8000,  // 256 KiB / 8 bytes = 0x8000 entries
    longint unsigned WIDTH       = 64
) {
    desc = "SEP scratch SRAM.";

    mementries = NUM_ENTRIES;
    memwidth   = WIDTH;

    // a single word of the memory
    reg mem_word {
        regwidth = 64;
        field {
           sw=rw;
           hw=rw;
        } data[WIDTH-1:0];
    };

    // the entire memory is an array of memory words
    mem_word mem_array[NUM_ENTRIES];

};

`endif
