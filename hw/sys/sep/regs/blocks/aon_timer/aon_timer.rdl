// SPDX-License-Identifier: Apache-2.0
// (c) 2026 Tenstorrent USA Inc

addrmap aon_timer {
    addrmap {
        reg {
            field {
                sw = w;
                hw = r;
                swmod = true;
                desc = "Write 1 to trigger one alert event of this kind.";
            } FATAL_FAULT[0:0] = 0x0;
        } external ALERT_TEST @ 0x0;
        reg {
            field {
                sw = rw;
                hw = r;
                desc = "When set to 1, the wakeup timer will count";
            } ENABLE[0:0] = 0x0;
            field {
                sw = rw;
                hw = r;
                swmod = true;
                desc = "Pre-scaler value for wakeup timer count";
            } PRESCALER[12:1] = 0x0;
        } WKUP_CTRL @ 0x4;
        reg {
            field {
                sw = rw;
                hw = r;
                desc = "The count at which a wakeup interrupt should be generated, top 32 bits.";
            } THRESHOLD_HI[31:0] = 0x0;
        } WKUP_THOLD_HI @ 0x8;
        reg {
            field {
                sw = rw;
                hw = r;
                desc = "The count at which a wakeup interrupt should be generated, bottom 32 bits.";
            } THRESHOLD_LO[31:0] = 0x0;
        } WKUP_THOLD_LO @ 0xC;
        reg {
            field {
                sw = rw;
                hw = rw;
                desc = "The current wakeup counter value, top 32 bits.";
            } COUNT_HI[31:0] = 0x0;
        } WKUP_COUNT_HI @ 0x10;
        reg {
            field {
                sw = rw;
                hw = rw;
                desc = "The current wakeup counter value, bottom 32 bits.";
            } COUNT_LO[31:0] = 0x0;
        } WKUP_COUNT_LO @ 0x14;
        reg {
            field {
                sw = rw;
                onwrite = wzc;
                hw = na;
                desc = "Once cleared, the watchdog configuration will be locked until the next reset.";
            } REGWEN[0:0] = 0x1;
        } WDOG_REGWEN @ 0x18;
        reg {
            field {
                sw = rw;
                hw = r;
                desc = "When set to 1, the watchdog timer will count.";
            } ENABLE[0:0] = 0x0;
            field {
                sw = rw;
                hw = r;
                desc = "When set to 1, the watchdog timer will not count during sleep.";
            } PAUSE_IN_SLEEP[1:1] = 0x0;
        } WDOG_CTRL @ 0x1C;
        reg {
            field {
                sw = rw;
                hw = r;
                desc = "The count at which a watchdog bark interrupt should be generated.";
            } THRESHOLD[31:0] = 0x0;
        } WDOG_BARK_THOLD @ 0x20;
        reg {
            field {
                sw = rw;
                hw = r;
                desc = "The count at which a watchdog bite reset should be generated.";
            } THRESHOLD[31:0] = 0x0;
        } WDOG_BITE_THOLD @ 0x24;
        reg {
            field {
                sw = rw;
                hw = rw;
                desc = "The current watchdog counter value.";
            } COUNT[31:0] = 0x0;
        } WDOG_COUNT @ 0x28;
        reg {
            field {
                sw = rw;
                onwrite = woclr;
                hw = rw;
                desc = "Raised if the wakeup timer has hit the specified threshold.";
            } WKUP_TIMER_EXPIRED[0:0] = 0x0;
            field {
                sw = rw;
                onwrite = woclr;
                hw = rw;
                desc = "Raised if the watchdog timer has hit the bark threshold.";
            } WDOG_TIMER_BARK[1:1] = 0x0;
        } INTR_STATE @ 0x2C;
        reg {
            field {
                sw = w;
                hw = r;
                swmod = true;
                desc = "Write 1 to force wkup_timer_expired interrupt.";
            } WKUP_TIMER_EXPIRED[0:0];
            field {
                sw = w;
                hw = r;
                swmod = true;
                desc = "Write 1 to force wdog_timer_bark interrupt.";
            } WDOG_TIMER_BARK[1:1];
        } external INTR_TEST @ 0x30;
        reg {
            field {
                sw = rw;
                onwrite = wzc;
                hw = rw;
                desc = "AON timer requested wakeup, write 0 to clear.";
            } CAUSE[0:0] = 0x0;
        } WKUP_CAUSE @ 0x34;
    } none @ 0x0;
};
