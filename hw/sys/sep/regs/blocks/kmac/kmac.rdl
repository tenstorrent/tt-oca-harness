// SPDX-License-Identifier: Apache-2.0
// SPDX-FileCopyrightText: 2026 Tenstorrent USA, Inc.

addrmap kmac {
    addrmap {
        reg {
            field {
                sw = rw;
                onwrite = woclr;
                hw = rw;
                desc = "KMAC/SHA3 absorbing has been completed";
            } KMAC_DONE[0:0] = 0x0;
            field {
                sw = r;
                hw = rw;
                desc = "The message FIFO is empty.
                This interrupt is raised only if the message FIFO is actually writable by software, i.e., if all of the following conditions are met:
                i) The KMAC block is not exercised by a hardware application interface.
                ii) The SHA3 block is in the Absorb state.
                iii) Software has not yet written the Process command to finish the absorption process.
                For the interrupt to be raised, the message FIFO must also have been full previously.
                Otherwise, the hardware empties the FIFO faster than software can fill it and there is no point in interrupting the software to inform it about the message FIFO being empty.";
            } FIFO_EMPTY[1:1] = 0x0;
            field {
                sw = rw;
                onwrite = woclr;
                hw = rw;
                desc = "KMAC/SHA3 error occurred. ERR_CODE register shows the details";
            } KMAC_ERR[2:2] = 0x0;
        } INTR_STATE @ 0x0;
        reg {
            field {
                sw = rw;
                hw = r;
                desc = "Enable interrupt when !!INTR_STATE.kmac_done is set.";
            } KMAC_DONE[0:0] = 0x0;
            field {
                sw = rw;
                hw = r;
                desc = "Enable interrupt when !!INTR_STATE.fifo_empty is set.";
            } FIFO_EMPTY[1:1] = 0x0;
            field {
                sw = rw;
                hw = r;
                desc = "Enable interrupt when !!INTR_STATE.kmac_err is set.";
            } KMAC_ERR[2:2] = 0x0;
        } INTR_ENABLE @ 0x4;
        reg {
            field {
                sw = w;
                hw = r;
                swmod = true;
                desc = "Write 1 to force !!INTR_STATE.kmac_done to 1.";
            } KMAC_DONE[0:0] = 0x0;
            field {
                sw = w;
                hw = r;
                swmod = true;
                desc = "Write 1 to force !!INTR_STATE.fifo_empty to 1.";
            } FIFO_EMPTY[1:1] = 0x0;
            field {
                sw = w;
                hw = r;
                swmod = true;
                desc = "Write 1 to force !!INTR_STATE.kmac_err to 1.";
            } KMAC_ERR[2:2] = 0x0;
        } external INTR_TEST @ 0x8;
        reg {
            field {
                sw = w;
                hw = r;
                swmod = true;
                desc = "Write 1 to trigger one alert event of this kind.";
            } RECOV_OPERATION_ERR[0:0] = 0x0;
            field {
                sw = w;
                hw = r;
                swmod = true;
                desc = "Write 1 to trigger one alert event of this kind.";
            } FATAL_FAULT_ERR[1:1] = 0x0;
        } external ALERT_TEST @ 0xC;
        reg {
            field {
                sw = r;
                hw = w;
                desc = "Configuration enable.";
            } EN[0:0] = 0x1;
        } external CFG_REGWEN @ 0x10;
        reg {
            shadowed = true;
            field {
                sw = rw;
                hw = r;
                swmod = true;
                desc = "KMAC datapath enable.

                If this bit is 1, the incoming message is processed in KMAC
                with the secret key.";
            } KMAC_EN[0:0] = 0x0;
            field {
                sw = rw;
                hw = r;
                swmod = true;
                desc = "Hashing Strength

                3 bit field to select the security strength of SHA3 hashing
                engine. If mode field is set to SHAKE or cSHAKE, only 128 and
                256 strength can be selected. Other value will result error
                when hashing starts.";
            } KSTRENGTH[3:1] = 0x0;
            field {
                sw = rw;
                hw = r;
                swmod = true;
                desc = "Keccak hashing mode.

                This module supports SHA3 main hashing algorithm and the part
                of its derived functions, SHAKE and cSHAKE with limitations.
                This field is to select the mode.";
            } MODE[5:4] = 0x0;
            field {
                sw = rw;
                hw = r;
                swmod = true;
                desc = "Message Endianness.

                If 1 then each individual multi-byte value, regardless of its
                alignment, written to !!MSG_FIFO will be added to the message
                in big-endian byte order.
                If 0, each value will be added to the message in little-endian
                byte order.
                A message written to !!MSG_FIFO one byte at a time will not be
                affected by this setting.
                From a hardware perspective byte swaps are performed on a TL-UL
                word granularity.";
            } MSG_ENDIANNESS[8:8] = 0x0;
            field {
                sw = rw;
                hw = r;
                swmod = true;
                desc = "State Endianness.

                If 1 then each individual word in the !!STATE output register
                is converted to big-endian byte order.
                The order of the words in relation to one another is not
                changed.
                This setting does not affect how the state is interpreted
                during computation.";
            } STATE_ENDIANNESS[9:9] = 0x0;
            field {
                sw = rw;
                hw = r;
                swmod = true;
                desc = "Sideloaded Key. Deprecated: defaults to 1 (sideload). Set to 0 for DV testing with SW key path only.

                If 1, KMAC uses KeyMgr sideloaded key for SW initiated KMAC
                operation. KMAC uses the sideloaded key regardless of this
                configuration when KeyMgr initiates the KMAC operation for
                Key Derivation Function (KDF).";
            } SIDELOAD[12:12] = 0x1;
            field {
                sw = rw;
                hw = r;
                swmod = true;
                desc = "Entropy Mode

                Using this field, software can configure mode of operation of the internal pseudo-random number generator (PRNG).

                Note that once software has configured a value different from `idle_mode` after reset, and set the !!CFG_SHADOWED.entropy_ready bit afterwards, the PRNG configuration cannot be changed anymore (unless an EDN request timeout occurs when running in EDN mode).
                Further writes to this field will change the value received upon reading the register, but they will be ignored by the internal hardware.";
            } ENTROPY_MODE[17:16] = 0x0;
            field {
                sw = rw;
                hw = r;
                swmod = true;
                desc = "Entropy Fast process mode.

                If 1, entropy logic uses garbage data while not processing the KMAC
                key block. It will re-use previous entropy value and will not
                expand the entropy when it is consumed. Only it refreshes the
                entropy while processing the secret key block. This process should
                not be used if SCA resistance is required because it may cause side
                channel leakage.";
            } ENTROPY_FAST_PROCESS[19:19] = 0x0;
            field {
                sw = rw;
                hw = r;
                swmod = true;
                desc = "Message Masking with PRNG.

                If 1, KMAC applies PRNG to the input messages to the Keccak module
                when KMAC mode is on.";
            } MSG_MASK[20:20] = 0x0;
            field {
                sw = rw;
                hw = r;
                swmod = true;
                desc = "Entropy Ready status.

                Software sets this field to allow the entropy generator in KMAC to
                fetch the entropy and run.";
            } ENTROPY_READY[24:24] = 0x0;
            field {
                sw = rw;
                hw = r;
                swmod = true;
                desc = "Enable Unsupported Mode and Strength configs.

                SW may set this field for KMAC to move forward with unsupported
                Keccak Mode and Strength configurations, such as cSHAKE512.

                If not set, KMAC won't propagate the SW command (CmdStart) to the
                rest of the blocks (AppIntf, KMAC Core, SHA3).";
            } EN_UNSUPPORTED_MODESTRENGTH[26:26] = 0x0;
        } CFG_SHADOWED @ 0x14;
        reg {
            field {
                sw = w;
                onwrite = woclr;
                hw = r;
                swmod = true;
                desc = "Issue a command to the KMAC/SHA3 IP. The command is sparse
                encoded. To prevent sw from writing multiple commands at once,
                the field is defined as enum.";
            } CMD[5:0];
            field {
                sw = w;
                onwrite = woclr;
                hw = r;
                swmod = true;
                desc = "Software can set this bit to 1 to manually trigger the reseeding of the internal PRNG when running in EDN mode.
                This will also clear !!ENTROPY_REFRESH_HASH_CNT.

                Note that the hardware may miss the trigger pulse if the module is not idle, or if the module is currently performing a reseed operation.";
            } ENTROPY_REQ[8:8];
            field {
                sw = w;
                onwrite = woclr;
                hw = r;
                swmod = true;
                desc = "Software can set this bit to 1 to manually clear !!ENTROPY_REFRESH_HASH_CNT.";
            } HASH_CNT_CLR[9:9];
            field {
                sw = w;
                onwrite = woclr;
                hw = r;
                swmod = true;
                desc = "When error occurs and one of the state machine stays at
                 Error handling state, SW may process the error based on
                 ERR_CODE, then let FSM back to the reset state";
            } ERR_PROCESSED[10:10];
        } external CMD @ 0x18;
        reg {
            field {
                sw = r;
                hw = w;
                desc = "If 1, SHA3 hashing engine is in idle state.";
            } SHA3_IDLE[0:0] = 0x1;
            field {
                sw = r;
                hw = w;
                desc = "If 1, SHA3 is receiving message stream and processing it";
            } SHA3_ABSORB[1:1];
            field {
                sw = r;
                hw = w;
                desc = "If 1, SHA3 completes sponge absorbing stage.
                In this stage, SW can manually run the hashing engine.";
            } SHA3_SQUEEZE[2:2];
            field {
                sw = r;
                hw = w;
                desc = "Count of occupied entries in the message FIFO.";
            } FIFO_DEPTH[12:8];
            field {
                sw = r;
                hw = w;
                desc = "Message FIFO Empty indicator.

                The FIFO's `Pass` parameter is set to `1'b 1`. So, by default, if
                the SHA engine is ready, the write data to FIFO just passes
                through.

                In this case, `fifo_depth` remains **0**. `fifo_empty`, however,
                lowers the value to **0** for a cycle, then goes back to the empty
                state, **1**.

                See the \"Message FIFO\" section in the spec for the reason.";
            } FIFO_EMPTY[14:14] = 0x1;
            field {
                sw = r;
                hw = w;
                desc = "Message FIFO Full indicator";
            } FIFO_FULL[15:15];
            field {
                sw = r;
                hw = w;
                desc = "No fatal fault has occurred inside the KMAC unit (0).
                A fatal fault has occurred and the KMAC unit needs to be reset (1),
                Examples for such faults include
                i) TL-UL bus integrity fault
                ii) storage errors in the shadow registers
                iii) errors in the message, round, or key counter
                iv) any internal FSM entering an invalid state
                v) an error in the redundant lfsr";
            } ALERT_FATAL_FAULT[16:16] = 0x0;
            field {
                sw = r;
                hw = w;
                desc = "An update error has not occurred (0) or has occurred (1) in the shadowed Control Register.
                KMAC operation needs to be restarted by re-writing the Control Register.";
            } ALERT_RECOV_CTRL_UPDATE_ERR[17:17] = 0x0;
        } external STATUS @ 0x1C;
        reg {
            field {
                sw = rw;
                hw = r;
                desc = "EDN Wait timer prescaler.

                EDN Wait timer has 16 bit value. The timer value is increased when the timer pulse is generated. Timer pulse is raises when the number of the clock cycles hit this prescaler value.

                The exact period of the timer pulse is unknown as the KMAC input clock may contain jitters.";
            } PRESCALER[9:0] = 0x0;
            field {
                sw = rw;
                hw = r;
                desc = "EDN request wait timer.

                The entropy module in KMAC waits up to this field in the timer pulse
                after it sends request to EDN module. If the timer expires, the
                entropy module moves to an error state and notifies to the system.

                If there is a pending EDN request during wait timer update, then this update is delayed until the EDN request is complete.

                If 0, the entropy module waits the EDN response always. If EDN does
                not respond in this configuration, the software shall reset the IP.";
            } WAIT_TIMER[31:16] = 0x0;
        } ENTROPY_PERIOD @ 0x20;
        reg {
            field {
                sw = r;
                hw = w;
                desc = "Hash (KMAC) counter";
            } HASH_CNT[9:0] = 0x0;
        } ENTROPY_REFRESH_HASH_CNT @ 0x24;
        reg {
            shadowed = true;
            field {
                sw = rw;
                hw = r;
                desc = "Hash Threshold";
            } THRESHOLD[9:0] = 0x0;
        } ENTROPY_REFRESH_THRESHOLD_SHADOWED @ 0x28;
        reg {
            field {
                sw = w;
                hw = r;
                swmod = true;
                desc = "32-bit chunk of the entropy generator seed";
            } SEED[31:0];
        } external ENTROPY_SEED @ 0x2C;
        reg {
            field {
                sw = w;
                hw = r;
                swmod = true;
                desc = "32-bit chunk of up-to 512-bit Secret Key";
            } KEY_0[31:0];
        } external KEY_SHARE0_0[16] @ 0x30 += 0x4;
        reg {
            field {
                sw = w;
                hw = r;
                swmod = true;
                desc = "32-bit chunk of up-to 512-bit Secret Key";
            } KEY_0[31:0];
        } external KEY_SHARE1_0[16] @ 0x70 += 0x4;
        reg {
            field {
                sw = w;
                hw = r;
                desc = "Key length choice";
            } LEN[2:0] = 0x0;
        } KEY_LEN @ 0xB0;
        reg {
            field {
                sw = rw;
                hw = r;
                desc = "32-bit chunk of Encoded NS Prefix";
            } PREFIX_0[31:0] = 0x0;
        } PREFIX_0[11] @ 0xB4 += 0x4;
        reg {
            field {
                sw = r;
                hw = w;
                desc = "If the `kmac_err` interrupt occurs, this register has information on the error cause.
                Bits 31:24 contain the error code (please refer to `err_code_e` in `hw/ip/kmac/rtl/kmac_pkg.sv`) for the encoding, and bits 23:0 contain additional debug information.
                This register does *not* get cleared when the `kmac_err` interrupt state gets cleared.";
            } ERR_CODE[31:0] = 0x0;
        } ERR_CODE @ 0xE0;
        mem {
            memwidth = 0x4;
        } external STATE[128] @ 0x400 += 0x1;
        mem {
            memwidth = 0x4;
        } external MSG_FIFO[512] @ 0x800 += 0x1;
    } none @ 0x0;
};
