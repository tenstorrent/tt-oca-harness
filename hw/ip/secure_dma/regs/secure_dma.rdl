`ifndef SECURE_DMA_RDL
`define SECURE_DMA_RDL

addrmap secure_dma {

    //////////////////
    // Enumerations //
    //////////////////

    enum asid_e {
        OT_ADDR  = 0x7 { desc = "OpenTitan 32-bit internal bus."; };
        SYS_ADDR = 0x9 { desc = "SoC system address bus using 64 bit SYS port."; };
        SOC_ADDR = 0xa { desc = "SoC control register bus using 32-bit (or 64 bits if configured by an SoC) control port."; };
    };

    enum transfer_width_e {
        ONE_BYTE  = 0x0 { desc = "One byte per transaction."; };
        TWO_BYTE  = 0x1 { desc = "Two bytes per transaction."; };
        FOUR_BYTE = 0x2 { desc = "Four bytes per transaction. Default value after reset."; };
    };

    enum opcode_e {
        COPY   = 0x0 { desc = "Copy Operation, Simple copy from source to destination."; };
        SHA256 = 0x1 { desc = "Perform inline hashing using SHA256."; };
        SHA384 = 0x2 { desc = "Perform inline hashing using SHA384."; };
        SHA512 = 0x3 { desc = "Perform inline hashing using SHA512."; };
    };

    desc = "Register map for the Secure DMA controller. This DMA supports memory-to-memory transfers, inline SHA2 hashing, hardware handshake mode, and interrupt source clearing.";

    reg INTR_STATE {
        desc = "Interrupt State Register";

        field {
            sw = r;
            hw = w;
            desc = "DMA operation has been completed.";
        } DMA_DONE[0:0] = 0x0;

        field {
            sw = r;
            hw = w;
            desc = "Indicates the transfer of a single chunk has been completed.";
        } DMA_CHUNK_DONE[1:1] = 0x0;

        field {
            sw = r;
            hw = w;
            desc = "DMA error has occurred. DMA_STATUS.error_code register shows the details.";
        } DMA_ERROR[2:2] = 0x0;
    };

    reg INTR_ENABLE {
        desc = "Interrupt Enable Register";

        field {
            sw = rw;
            hw = r;
            desc = "Enable interrupt when INTR_STATE.DMA_DONE is set.";
        } DMA_DONE[0:0] = 0x0;

        field {
            sw = rw;
            hw = r;
            desc = "Enable interrupt when INTR_STATE.DMA_CHUNK_DONE is set.";
        } DMA_CHUNK_DONE[1:1] = 0x0;

        field {
            sw = rw;
            hw = r;
            desc = "Enable interrupt when INTR_STATE.DMA_ERROR is set.";
        } DMA_ERROR[2:2] = 0x0;
    };

    reg INTR_TEST {
        desc = "Interrupt Test Register";

        field {
            sw = w;
            hw = r;
            singlepulse;
            desc = "Write 1 to force INTR_STATE.DMA_DONE to 1.";
        } DMA_DONE[0:0] = 0x0;

        field {
            sw = w;
            hw = r;
            singlepulse;
            desc = "Write 1 to force INTR_STATE.DMA_CHUNK_DONE to 1.";
        } DMA_CHUNK_DONE[1:1] = 0x0;

        field {
            sw = w;
            hw = r;
            singlepulse;
            desc = "Write 1 to force INTR_STATE.DMA_ERROR to 1.";
        } DMA_ERROR[2:2] = 0x0;
    };

    reg ALERT_TEST {
        desc = "Alert Test Register";

        field {
            sw = w;
            hw = r;
            singlepulse;
            desc = "Write 1 to trigger one alert event of this kind.";
        } FATAL_FAULT[0:0] = 0x0;
    };

    reg SRC_ADDR_LO {
        desc = "Lower 32 bits of the physical or virtual address of memory location within SoC memory address map or physical address within OT non-secure memory space. Data is read from this location in a copy operation. The address may be an IO virtual address. Must be aligned to the transfer width. Register enable: CFG_REGWEN.";

        field {
            sw = rw;
            hw = r;
            desc = "Lower 32 bits of the source address. Must be aligned to the transfer width.";
        } ADDR[31:0] = 0x0;
    };

    reg SRC_ADDR_HI {
        desc = "Upper 32 bits of the source address. Must be aligned to the transfer width. Source and destination address must have the same alignment. Register enable: CFG_REGWEN.";

        field {
            sw = rw;
            hw = r;
            desc = "Upper 32 bits of the physical or virtual address of memory location within SoC memory address map or physical address within OT non-secure memory space. Must be aligned to the transfer width. Source and destination address must have the same alignment.";
        } ADDR[31:0] = 0x0;
    };

    reg DST_ADDR_LO {
        desc = "Lower 32 bits of the physical or virtual address of memory location within SoC memory address map or physical address within OT non-secure memory space. Data is written to this location in a copy operation. The address may be an IO virtual address. Must be aligned to the transfer width. Source and destination address must have the same alignment. Register enable: CFG_REGWEN.";

        field {
            sw = rw;
            hw = r;
            desc = "Lower 32 bits of the destination address. Must be aligned to the transfer width. Source and destination address must have the same alignment.";
        } ADDR[31:0] = 0x0;
    };

    reg DST_ADDR_HI {
        desc = "Upper 32 bits of the destination address. Must be aligned to the transfer width. Source and destination address must have the same alignment. Register enable: CFG_REGWEN.";

        field {
            sw = rw;
            hw = r;
            desc = "Upper 32 bits of the physical or virtual address of memory location within SoC memory address map or physical address within OT non-secure memory space. Must be aligned to the transfer width. Source and destination address must have the same alignment.";
        } ADDR[31:0] = 0x0;
    };

    reg ADDR_SPACE_ID {
        desc = "Address spaces that source and destination pointers refer to. Register enable: CFG_REGWEN.";

        field {
            sw = rw;
            hw = r;
            encode = asid_e;
            desc = "Target address space that the source address pointer refers to.";
        } SRC_ASID[3:0] = 0x7;

        field {
            sw = rw;
            hw = r;
            encode = asid_e;
            desc = "Target address space that the destination address pointer refers to.";
        } DST_ASID[7:4] = 0x7;
    };

    reg ENABLED_MEMORY_RANGE_BASE {
        desc = "Base Address to mark the start of the DMA enabled memory range within the OT internal memory space. Register enable: RANGE_REGWEN.";

        field {
            sw = rw;
            hw = r;
            desc = "Base Address to mark the start of the DMA enabled memory range within the OT internal memory space.";
        } BASE[31:0] = 0x0;
    };

    reg ENABLED_MEMORY_RANGE_LIMIT {
        desc = "Limit Address to mark the end of the DMA enabled memory range within the OT internal memory space; address is inclusive. Register enable: RANGE_REGWEN.";

        field {
            sw = rw;
            hw = r;
            desc = "Limit Address to mark the end of the DMA enabled memory range within the OT internal memory space; inclusive.";
        } LIMIT[31:0] = 0x0;
    };

    reg RANGE_VALID {
        desc = "Indicates that the ENABLED_MEMORY_RANGE_BASE and _LIMIT registers have been programmed to restrict DMA accesses within the OT internal address space. Register enable: RANGE_REGWEN.";

        field {
            sw = rw;
            hw = r;
            desc = "Once set the enabled memory base and limit registers are valid.";
        } RANGE_VALID[0:0] = 0x0;
    };

    reg RANGE_REGWEN {
        desc = "Used to lock the DMA enabled memory range configuration registers.";

        field {
            sw = rw;
            hw = r;
            desc = "Used by firmware to lock the DMA enabled memory range configuration registers from further modification. Once this register is set to kMultiBitBool4False (0x9), it can only be set to kMultiBitBool4True (0x6) through a reset event. Default Value = kMultiBitBool4True (0x6) -> Unlocked at reset. Software can only clear bits (rw0c behavior).";
        } REGWEN[3:0] = 0x6;
    };

    reg CFG_REGWEN {
        desc = "Indicates whether the configuration registers are locked because the DMA controller is operating. In the idle state, this register is set to kMultiBitBool4True. When the DMA is performing an operation, i.e. the DMA is busy, this register is set to kMultiBitBool4False. During the DMA operation, the CONTROL and STATUS registers remain usable. The comportable registers (the interrupt and alert configuration) are NOT locked during the DMA operation and can still be updated. When the DMA reaches an interrupt or alert condition, it will perform the action according to the current register configuration.";

        field {
            sw = r;
            hw = w;
            desc = "Used by hardware to lock the DMA configuration registers. This register is purely managed by hardware and only software readable.";
        } REGWEN[3:0] = 0x6;
    };

    reg TOTAL_DATA_SIZE {
        desc = "Total size (in bytes) of the data to be transferred. Register enable: CFG_REGWEN.";

        field {
            sw = rw;
            hw = r;
            desc = "Total size (in bytes) of the data to be transferred. The complete transfer operation may consist of multiple chunks of data as specified by the CHUNK_DATA_SIZE register. Minimum: 1 byte. Maximum: May be restricted to a maximum pre-defined size based on OT DMA enabled memory space allocation. Works in conjunction with the TRANSFER_WIDTH register.";
        } SIZE[31:0] = 0x0;
    };

    reg CHUNK_DATA_SIZE {
        desc = "Number of bytes to be transferred in response to each interrupt/firmware request. Register enable: CFG_REGWEN.";

        field {
            sw = rw;
            hw = r;
            desc = "Size (in bytes) for a single DMA transfer. In hardware handshake mode, the DMA reads in chunks of CHUNK_DATA_SIZE from the peripheral. For a single memory transfer CHUNK_DATA_SIZE and TOTAL_DATA_SIZE are set to the same value. Minimum: 1 byte. Maximum: May be restricted to a maximum pre-defined size based on OT DMA enabled memory space allocation. Works in conjunction with the TRANSFER_WIDTH register.";
        } SIZE[31:0] = 0x0;
    };

    reg TRANSFER_WIDTH {
        desc = "Denotes the width of each transaction that the DMA shall issue. Register enable: CFG_REGWEN.";

        field {
            sw = rw;
            hw = r;
            encode = transfer_width_e;
            desc = "Denotes the width of each transaction that the DMA shall issue during the data movement. Multiple transactions of this width will be issued until TOTAL_DATA_SIZE bytes have been transferred. Note that firmware may need to set a different value if a receiving IP supports a read / write transaction width that is less than 1 DWORD. This does not affect the wrap-around mechanism. Note that the value 3 for this register represents an invalid configuration that leads to an error.";
        } WIDTH[1:0] = 0x2;
    };

    reg CONTROL {
        desc = "Control register for DMA data movement.";

        field {
            sw = rw;
            hw = r;
            encode = opcode_e;
            desc = "Defines the type of DMA operations.";
        } OPCODE[3:0] = 0x0;

        field {
            sw = rw;
            hw = r;
            desc = "Enable hardware handshake mode. Used to clear FIFOs from low speed IO peripherals receiving data, e.g., I3C receive buffer. Listen to an input trigger signal. Read data from source address location. Copy to destination address. Number of bytes specified in size register. Note assumption is the peripheral lowers input once FIFO is cleared. No explicit clearing necessary.";
        } HARDWARE_HANDSHAKE_ENABLE[4:4] = 0x0;

        field {
            sw = rw;
            hw = r;
            desc = "Digest register byte swap. If 1 the value in each digest output register is converted to big-endian byte order. This setting does not affect the order of the digest output registers, SHA2_DIGEST_0 still contains the first 4 bytes of the digest.";
        } DIGEST_SWAP[5:5] = 0x0;

        field {
            sw = rw;
            hw = r;
            desc = "Marks the initial transfer to initialize the DMA and SHA engine for one transfer that can span over multiple single DMA transfers. Used for hardware handshake and ordinary transfers, in which multiple transfers contribute to a final digest. Note, for non-handshake transfers with inline hashing mode enabled, this bit must be set to also mark the first transfer.";
        } INITIAL_TRANSFER[8:8] = 0x0;

        field {
            sw = w;
            hw = r;
            desc = "Aborts the DMA operation if this bit is set. Sets the corresponding bit in the status register once abort operation is complete. Any OpenTitan-internal transactions are guaranteed to complete, but there are no guarantees on the SoC interface.";
        } ABORT[27:27] = 0x0;

        field {
            sw = rw;
            hw = r;
            desc = "Setting this bit triggers the DMA operation. For normal operation, the DMA engine clears the go bit automatically after the configured operation is complete. For Hardware handshake operation, DMA engine does not auto clear the Go bit. Firmware shall clear the Go bit when it intends to stop the hardware handshake operation.";
        } GO[31:31] = 0x0;
    };

    reg SRC_CONFIG {
        desc = "Defines the addressing behavior of the DMA for the source address. Register enable: CFG_REGWEN.";

        field {
            sw = rw;
            hw = r;
            desc = "Defines the increment behavior after every DMA read. When 0: Source address is not changed. All reads are done from the same address. When 1: Source address is incremented by transfer_width after each read.";
        } INCREMENT[0:0] = 0x0;

        field {
            sw = rw;
            hw = r;
            desc = "When 0: Chunks occupy contiguous ascending addresses. When 1: Source address wraps back to the starting address when finishing a chunk.";
        } WRAP[1:1] = 0x0;
    };

    reg DST_CONFIG {
        desc = "Defines the addressing behavior of the DMA for the destination address. Register enable: CFG_REGWEN.";

        field {
            sw = rw;
            hw = r;
            desc = "Defines the increment behavior after every DMA write. When 0: Destination address is not changed. All writes are done to the same address. When 1: Destination address is incremented by transfer_width after each write.";
        } INCREMENT[0:0] = 0x0;

        field {
            sw = rw;
            hw = r;
            desc = "When 0: Chunks occupy contiguous ascending addresses. When 1: Destination address wraps back to the starting address when finishing a chunk.";
        } WRAP[1:1] = 0x0;
    };

    reg STATUS {
        desc = "Status indication for DMA data movement.";

        field {
            sw = r;
            hw = w;
            desc = "DMA operation is active if this bit is set. DMA engine clears this bit when operation is complete. This bit may be set as long as hardware handshake mode is active and triggered.";
        } BUSY[0:0] = 0x0;

        field {
            sw = rw;
            hw = w;
            onwrite = woclr;
            desc = "Configured DMA operation is complete. Cleared automatically by the hardware when starting a new transfer.";
        } DONE[1:1] = 0x0;

        field {
            sw = rw;
            hw = w;
            onwrite = woclr;
            desc = "Set once aborted operation drains.";
        } ABORTED[2:2] = 0x0;

        field {
            sw = rw;
            hw = w;
            onwrite = woclr;
            desc = "Error occurred during the operation. ERROR_CODE register denotes the source of the error.";
        } ERROR[3:3] = 0x0;

        field {
            sw = r;
            hw = w;
            desc = "Indicates whether the SHA2_DIGEST register contains a valid digest. This value is cleared on the initial transfer and set when the digest is written.";
        } SHA2_DIGEST_VALID[4:4] = 0x0;

        field {
            sw = rw;
            hw = w;
            onwrite = woclr;
            desc = "Transfer of a single chunk is complete. Only raised for multi-chunk memory-to-memory transfers. Cleared automatically by the hardware when starting the transfer of a new chunk.";
        } CHUNK_DONE[5:5] = 0x0;
    };

    reg ERROR_CODE {
        desc = "Denotes the source of the operational error. The error is cleared by writing the RW1C STATUS.error register.";

        field {
            sw = r;
            hw = w;
            desc = "Source address is invalid.";
        } SRC_ADDR_ERROR[0:0] = 0x0;

        field {
            sw = r;
            hw = w;
            desc = "Destination address is invalid.";
        } DST_ADDR_ERROR[1:1] = 0x0;

        field {
            sw = r;
            hw = w;
            desc = "Opcode is invalid.";
        } OPCODE_ERROR[2:2] = 0x0;

        field {
            sw = r;
            hw = w;
            desc = "TRANSFER_WIDTH encodes an invalid value, TOTAL_DATA_SIZE or CHUNK_SIZE are zero, or inline hashing is not using 32-bit transfer width";
        } SIZE_ERROR[3:3] = 0x0;

        field {
            sw = r;
            hw = w;
            desc = "The bus transfer returned an error.";
        } BUS_ERROR[4:4] = 0x0;

        field {
            sw = r;
            hw = w;
            desc = "The base and limit addresses contain an invalid value.";
        } BASE_LIMIT_ERROR[5:5] = 0x0;

        field {
            sw = r;
            hw = w;
            desc = "The DMA enabled memory range is not configured.";
        } RANGE_VALID_ERROR[6:6] = 0x0;

        field {
            sw = r;
            hw = w;
            desc = "The source or destination ASID contains an invalid value.";
        } ASID_ERROR[7:7] = 0x0;
    };

    reg SHA2_DIGEST {
        desc = "Digest register for the inline hashing operation. Depending on the used hashing mode, not all registers are used. SHA256: Digest is stored in registers 0 to 7. SHA384: Digest is stored in registers 0 to 11. SHA512: Digest is stored in registers 0 to 15.";

        field {
            sw = r;
            hw = w;
            desc = "SHA2 digest data";
        } DATA[31:0] = 0x0;
    };

    reg HANDSHAKE_INTR_ENABLE {
        desc = "Enable bits for incoming handshake interrupt wires. Register enable: CFG_REGWEN.";

        field {
            sw = rw;
            hw = r;
            desc = "Enable bits for incoming handshake interrupt wires.";
        } MASK[10:0] = 0x7ff;
    };

    reg CLEAR_INTR_SRC {
        desc = "Valid bits for which interrupt sources need clearing. When HANDSHAKE_INTR_ENABLE is non-zero and corresponding lsio_trigger becomes set, DMA issues writes with address from INTR_SRC_ADDR and write value from INTR_SRC_WR_VAL corresponding to each bit set in this register. Register enable: CFG_REGWEN.";

        field {
            sw = rw;
            hw = r;
            desc = "Source N needs interrupt cleared";
        } SOURCE[10:0] = 0x0;
    };

    reg CLEAR_INTR_BUS {
        desc = "Bus selection bit where the clearing command should be performed. 0: CTN/System fabric. 1: OT-internal crossbar. Register enable: CFG_REGWEN.";

        field {
            sw = rw;
            hw = r;
            desc = "Bus selection bit for source N.";
        } BUS[10:0] = 0x0;
    };

    reg INTR_SRC_ADDR {
        desc = "Destination address for interrupt source clearing write. Register enable: CFG_REGWEN.";

        field {
            sw = rw;
            hw = r;
            desc = "Destination address for interrupt source clearing write.";
        } ADDR[31:0] = 0x0;
    };

    reg INTR_SRC_WR_VAL {
        desc = "Write value for interrupt clearing write. Register enable: CFG_REGWEN.";

        field {
            sw = rw;
            hw = r;
            desc = "Write value for interrupt clearing write.";
        } WR_VAL[31:0] = 0x0;
    };

    /////////////////
    // Address Map //
    /////////////////

    INTR_STATE                 INTR_STATE                 @0x0;
    INTR_ENABLE                INTR_ENABLE                @0x4;
    INTR_TEST                  INTR_TEST                  @0x8;
    ALERT_TEST                 ALERT_TEST                 @0xc;
    SRC_ADDR_LO                SRC_ADDR_LO                @0x10;
    SRC_ADDR_HI                SRC_ADDR_HI                @0x14;
    DST_ADDR_LO                DST_ADDR_LO                @0x18;
    DST_ADDR_HI                DST_ADDR_HI                @0x1c;
    ADDR_SPACE_ID              ADDR_SPACE_ID              @0x20;
    ENABLED_MEMORY_RANGE_BASE  ENABLED_MEMORY_RANGE_BASE  @0x24;
    ENABLED_MEMORY_RANGE_LIMIT ENABLED_MEMORY_RANGE_LIMIT @0x28;
    RANGE_VALID                RANGE_VALID                @0x2c;
    RANGE_REGWEN               RANGE_REGWEN               @0x30;
    CFG_REGWEN                 CFG_REGWEN                 @0x34;
    TOTAL_DATA_SIZE            TOTAL_DATA_SIZE            @0x38;
    CHUNK_DATA_SIZE            CHUNK_DATA_SIZE            @0x3c;
    TRANSFER_WIDTH             TRANSFER_WIDTH             @0x40;
    CONTROL                    CONTROL                    @0x44;
    SRC_CONFIG                 SRC_CONFIG                 @0x48;
    DST_CONFIG                 DST_CONFIG                 @0x4c;
    STATUS                     STATUS                     @0x50;
    ERROR_CODE                 ERROR_CODE                 @0x54;
    SHA2_DIGEST                SHA2_DIGEST_0              @0x58;
    SHA2_DIGEST                SHA2_DIGEST_1              @0x5c;
    SHA2_DIGEST                SHA2_DIGEST_2              @0x60;
    SHA2_DIGEST                SHA2_DIGEST_3              @0x64;
    SHA2_DIGEST                SHA2_DIGEST_4              @0x68;
    SHA2_DIGEST                SHA2_DIGEST_5              @0x6c;
    SHA2_DIGEST                SHA2_DIGEST_6              @0x70;
    SHA2_DIGEST                SHA2_DIGEST_7              @0x74;
    SHA2_DIGEST                SHA2_DIGEST_8              @0x78;
    SHA2_DIGEST                SHA2_DIGEST_9              @0x7c;
    SHA2_DIGEST                SHA2_DIGEST_10             @0x80;
    SHA2_DIGEST                SHA2_DIGEST_11             @0x84;
    SHA2_DIGEST                SHA2_DIGEST_12             @0x88;
    SHA2_DIGEST                SHA2_DIGEST_13             @0x8c;
    SHA2_DIGEST                SHA2_DIGEST_14             @0x90;
    SHA2_DIGEST                SHA2_DIGEST_15             @0x94;
    HANDSHAKE_INTR_ENABLE      HANDSHAKE_INTR_ENABLE      @0x98;
    CLEAR_INTR_SRC             CLEAR_INTR_SRC             @0x9c;
    CLEAR_INTR_BUS             CLEAR_INTR_BUS             @0xa0;
    INTR_SRC_ADDR              INTR_SRC_ADDR_0            @0xa4;
    INTR_SRC_ADDR              INTR_SRC_ADDR_1            @0xa8;
    INTR_SRC_ADDR              INTR_SRC_ADDR_2            @0xac;
    INTR_SRC_ADDR              INTR_SRC_ADDR_3            @0xb0;
    INTR_SRC_ADDR              INTR_SRC_ADDR_4            @0xb4;
    INTR_SRC_ADDR              INTR_SRC_ADDR_5            @0xb8;
    INTR_SRC_ADDR              INTR_SRC_ADDR_6            @0xbc;
    INTR_SRC_ADDR              INTR_SRC_ADDR_7            @0xc0;
    INTR_SRC_ADDR              INTR_SRC_ADDR_8            @0xc4;
    INTR_SRC_ADDR              INTR_SRC_ADDR_9            @0xc8;
    INTR_SRC_ADDR              INTR_SRC_ADDR_10           @0xcc;
    INTR_SRC_WR_VAL            INTR_SRC_WR_VAL_0          @0x124;
    INTR_SRC_WR_VAL            INTR_SRC_WR_VAL_1          @0x128;
    INTR_SRC_WR_VAL            INTR_SRC_WR_VAL_2          @0x12c;
    INTR_SRC_WR_VAL            INTR_SRC_WR_VAL_3          @0x130;
    INTR_SRC_WR_VAL            INTR_SRC_WR_VAL_4          @0x134;
    INTR_SRC_WR_VAL            INTR_SRC_WR_VAL_5          @0x138;
    INTR_SRC_WR_VAL            INTR_SRC_WR_VAL_6          @0x13c;
    INTR_SRC_WR_VAL            INTR_SRC_WR_VAL_7          @0x140;
    INTR_SRC_WR_VAL            INTR_SRC_WR_VAL_8          @0x144;
    INTR_SRC_WR_VAL            INTR_SRC_WR_VAL_9          @0x148;
    INTR_SRC_WR_VAL            INTR_SRC_WR_VAL_10         @0x14c;
};

`endif
