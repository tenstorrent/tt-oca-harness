// SPDX-License-Identifier: Apache-2.0
// SPDX-FileCopyrightText: 2026 Tenstorrent USA, Inc.

`ifndef AXIL_MAILBOX_RDL
`define AXIL_MAILBOX_RDL

addrmap axil_mailbox {
    desc = "";

    ////////////////////////////////////////////////////////////////////////////
    // Register Definitions
    ////////////////////////////////////////////////////////////////////////////


    reg WRITE_DATA {
        regwidth = 64;
        accesswidth = 64;
        field {
            sw = w;
            hw = r;
            desc = "Write data to mailbox fifo";
        } write_data [63:0] = 0x0;
    };

    reg READ_DATA {
        regwidth = 64;
        accesswidth = 64;
        field {
            sw = r;
            hw = r;
            desc = "Read data from mailbox fifo";
        } read_data [63:0] = 0x0;
    };

   reg STATUS {
        regwidth = 64;
        accesswidth = 64;
        field {
            sw = r;
            hw = r;
            desc = "0: Data is available to read, 1: Data is not available to read";
        } empty [0:0] = 0x0;

        field {
            sw = r;
            hw = r;
            desc = "0: Space is available to write, 1: Space is not available to write";
        } full [1:1] = 0x0;

        field {
            sw = r;
            hw = r;
            desc = "If set, write fifo level is higher than threshold set in WIRQT";
        } write_level_above_thresh [2:2] = 0x0;

        field {
            sw = r;
            hw = r;
            desc = "If set, read fifo level is higher than threshold set in RIRQT";
        } read_level_above_thresh [3:3] = 0x0;
    };

    reg ERROR {
        regwidth = 64;
        accesswidth = 64;
        field {
            sw = r;
            hw = r;
            desc = "Attempted write to a full mailbox";
        } write_error [1:1] = 0x0;

        field {
            sw = r;
            hw = r;
            desc = "Attempted read from an empty mailbox";
        } read_error [0:0] = 0x0;
    };

    reg WIRQT {
        regwidth = 64;
        accesswidth = 64;
        field {
            sw = rw;
            hw = r;
            desc = "When the usage pointer of the FIFO connected to the W channel exceeds this value, a write threshold IRQ is triggered and the corresponding STATUS register bit is set. When a value larger than or equal to the MailboxDepth parameter is written to this register, it gets reduced to MailboxDepth - 1 to ensure an IRQ is triggered when the write FIFO is full.";
        } wirqt [7:0] = 0x0;
    };

    reg RIRQT {
        regwidth = 64;
        accesswidth = 64;
        field {
            sw = rw;
            hw = r;
            desc = "When the fill pointer of the FIFO connected to the R channel exceeds this value, a read threshold IRQ is triggered and the corresponding STATUS register bit is set. When a value larger than or equal to the MailboxDepth parameter is written to this register, it gets reduced to MailboxDepth - 1 to ensure an IRQ is triggered when the read FIFO is full.";
        } rirqt [7:0] = 0x0;
    };

    reg IRQS {
        regwidth = 64;
        accesswidth = 64;

        desc = "This register is used to read and clear interrupt requests, regardless of IRQEN register and whether the interrupt is enabled or disabled.";

        field {
            sw = rw;
            hw = r;
            desc = "On read:
                    [0]: No interrupt request
                    [1]: Error on mailbox access
                    On write:
                    [0]: No acknowledge
                    [1]: Acknowledge and clear interrupt request";
        } eirq [2:2] = 0x0;

        field {
            sw = rw;
            hw = r;
            desc = "On read:
                    [0]: No interrupt request
                    [1]: Usage level threshold in read mailbox exceeded
                    On write:
                    [0]: No acknowledge
                    [1]: Acknowledge and clear interrupt request";
        } rtirq [1:1] = 0x0;

        field {
            sw = rw;
            hw = r;
            desc = "On read:
                    [0]: No interrupt request
                    [1]: Usage level threshold in write mailbox exceeded
                    On write:
                    [0]: No acknowledge
                    [1]: Acknowledge and clear interrupt request";
        } wtirq [0:0] = 0x0;
    };

    reg IRQEN {
        regwidth = 64;
        accesswidth = 64;

        desc = "This register is used to enable and disable which interrupts are sent to the CPU.";

        field {
            sw = rw;
            hw = r;
            desc = "[0]: Error IRQ disabled
                    [1]: Error IRQ enabled";
        } eirq [2:2] = 0x0;

        field {
            sw = rw;
            hw = r;
            desc = "[0]: Read threshold IRQ disabled
                    [1]: Read threshold IRQ enabled";
        } rtirq [1:1] = 0x0;

        field {
            sw = rw;
            hw = r;
            desc = "[0]: Write threshold IRQ disabled
                    [1]: Write threshold IRQ enabled";
        } wtirq [0:0] = 0x0;
    };

    reg IRQP {
        regwidth = 64;
        accesswidth = 64;

        desc = "This register is used to read the current status of the interrupts sent to the CPU.";

        field {
            sw = r;
            hw = r;
            desc = "[0]: No error IRQ pending
                    [1]: Error IRQ pending";
        } eirq [2:2] = 0x0;

        field {
            sw = r;
            hw = r;
            desc = "[0]: No read threshold IRQ pending
                    [1]: Read threshold IRQ pending";
        } rtirq [1:1] = 0x0;

        field {
            sw = r;
            hw = r;
            desc = "[0]: No write threshold IRQ pending
                    [1]: Write threshold IRQ pending";
        } wtirq [0:0] = 0x0;
    };

    reg CTRL {
        regwidth = 64;
        accesswidth = 64;
        field {
            sw = w;
            hw = r;
            desc = "Flush the read FIFO for this port";
        } rflush [1:1] = 0x0;

        field {
            sw = w;
            hw = r;
            desc = "Flush the write FIFO for this port";
        } wflush [0:0] = 0x0;
    };

    ////////////////////////////////////////////////////////////////////////////
    // Address Map
    ////////////////////////////////////////////////////////////////////////////

    WRITE_DATA WRITE_DATA    @0x0;
    READ_DATA  READ_DATA     @0x8;
    STATUS     STATUS        @0x10;
    ERROR      ERROR_FLAGS   @0x18;
    WIRQT      WIRQT         @0x20;
    RIRQT      RIRQT         @0x28;
    IRQS       IRQS          @0x30;
    IRQEN      IRQEN         @0x38;
    IRQP       IRQP          @0x40;
    CTRL       CTRL          @0x48;
};

`endif
