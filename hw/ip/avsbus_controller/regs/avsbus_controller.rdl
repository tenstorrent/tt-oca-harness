// SPDX-License-Identifier: Apache-2.0
// SPDX-FileCopyrightText: 2026 Tenstorrent USA, Inc.

`ifndef AVS_CONTROLLER_RDL_DEFINED
`define AVS_CONTROLLER_RDL_DEFINED

addrmap avsbus_controller {

   desc = "AVSBus V1.3.1 Registers";

   ////////////////////////////////////////////////////////////////////////////
   // Register Definitions
   ////////////////////////////////////////////////////////////////////////////

   reg AVS_CMD {
      desc = "The command+data to be transferred to the AVS bus";

      field {
         sw = w;
         hw = r;
         desc = "Read or write type: [list]
                  [*]0x0 - Commit Write
                  [*]0x1 - Hold Write
                  [*]0x2 - Read
                  [/list]";
      } R_OR_W[29:28] = 0x0;

      field {
         sw = w;
         hw = r;
         desc = "Command group:
                     Set to 1 for manufacturer-specific Command Code (cmd_code), otherwise 0";
      } CMD_GRP[27:27] = 0x0;

      field {
         sw = w;
         hw = r;
         desc = "Command Code (For cmd_group=0. For cmd_group=1, this is manufacturer-specific): [list]
                  [*]0x0 - Target Rail Voltage Read/Write
                  [*]0x1 - Vout Transition Rate Read/Write
                  [*]0x2 - Rail Current Read
                  [*]0x3 - Temperature Read
                  [*]0x4 - Force Voltage Reset (Requires wr_cmd_data=0x0)
                  [*]0x5 - Power Mode Read/Write
                  [*]0xe - AVSBus Status Read/Write
                  [*]0xf - AVSBus Version Read
                  [/list]";

      } CMD_CODE[26:23] = 0x0;

      field {
         sw = w;
         hw = r;
         desc = "Rail Select:
                  0x0 - Rail 0
                  0x1 - Rail 1
                  0xf - Broadcast";
      } RAIL_SEL[22:19] = 0x0;

      field {
         sw = w;
         hw = r;
         desc = "Write Cmd Data. Formats: [list]
                  [*]Voltage (cmd_code 0x0): 16-bit unsigned int, 1LSB=1mV
                  [*]Transition Rate (cmd_code 0x1): [list]
                     [*]MSByte: Rise Rate, 8-bit unsigned int, 1LSB=1mV/us
                     [*]LSByte: Fall Rate, 8-bit unsigned int, 1LSB=1mV/us [/list]
                  [*]Reset Voltage (cmd_code 0x4): 16-bits, all zeroes
                  [*]Power Mode (cmd_code 0x5): 3-bits, LSB aligned: [list]
                     [*]0x0 - Maximum Efficiency
                     [*]0x3 - Maximum Power
                     [*]0x4-0x7 - Manufacturer-specific  [/list]
                  [*]AVSBus Status (cmd_code 0xe): 16-bits, encoded per AVS Spec
                  [*]AVSBus Version (cmd_code 0xf): 4 bits encoded per AVS Spec, LSB-aligned
                  [*]For read cmd_code's, this is 0xffff
                  [/list]";

      } CMD_DATA[18:3] = 0x0;
   };


   reg AVS_READBACK {
      desc = "Response data from AVS slave device (updated in response to both AVS read and write commands). Reading
               this register causes the AVS response readback fifo pointer to advance.";

      field {
         sw = r;
         hw = w;
         onread = ruser;
         desc = "Indicates whether command executed or not - codes 0x1 and 0x2 trigger automatic retries by hardware:  [list]
                     [*]0x0: Action Performed
                     [*]0x1: Good CRC received but resource unavailable - hardware will retry
                     [*]0x2: Bad CRC received - hardware will retry
                     [*]0x3: Good CRC received but bad data, data type or selector - no hardware retry
                     [/list]";

      } SLAVE_ACK[31:30] = 0x0;

      field {
         sw = r;
         hw = w;
         onread = ruser;
         desc = "Always 0";
      } CONST0[29:29] = 0x0;

      field {
         sw = r;
         hw = w;
         onread = ruser;
         desc = "5-bit field indicating general condition of the slave, per AVS spec StatusReponse field: [list]
                     [*]bit 4: VDone - AND of all VDone bits of active rails
                     [*]bit 3: StatusAlert - Indicates potential status issue, requiring AVSBus Status read cmd for details
                     [*]bit 2: AVS_Control - 1 if ABSBus is controlling at least 1 device output, 0 otherwise.
                     [*]bit 1: MfrSpcfc_Stts1 - Manufacturer-specific
                     [*]bit 0: MfrSpcfc_Stts2 - Manufacturer-specific
                     [/list]";
      } STATUS_RESPONSE[28:24] = 0x0;

      field {
         sw = r;
         hw = w;
         onread = ruser;
         desc = "Read Cmd Data. Format depends on cmd_code in previous master subframe:[list]
                  [*]Voltage (cmd_code 0x0): 16-bit unsigned int, 1LSB=1mV
                  [*]Transition Rate (cmd_code 0x1): [list]
                     [*]MSByte: Rise Rate, 8-bit unsigned int, 1LSB=1mV/us
                     [*]LSByte: Fall Rate, 8-bit unsigned int, 1LSB=1mV/us [/list]
                  [*]Current (cmd_mode 0x2): 16-bit unsigned, 1LSB=10mA
                  [*]Temperature (cmd_code 0x3): 16-bit signed, 1LSB=0.1degC
                  [*]Power Mode (cmd_code 0x5): 3-bits, LSB aligned: [list]
                     [*]0x0 - Maximum Efficiency
                     [*]0x3 - Maximum Power
                     [*]0x4-0x7 - Manufacturer-specific  [/list]
                  [*]AVSBus Status (cmd_code 0xe): 16-bits, encoded per AVS Spec
                  [*]AVSBus Version (cmd_code 0xf): 4 bits encoded per AVS Spec, LSB-aligned
                  [*]If master issued a write (rw!=0x2) in previous master subframe, this field is 0xffff
                  [/list]";
      } CMD_DATA[23:8] = 0x0;

      field {
         sw = r;
         hw = w;
         onread = ruser;
         desc = "The CRC-3 code received from slave";
      } CRC[2:0] = 0x0;
   };


   reg AVS_DEBUG_READBACK {
      desc = "This register mirrors the AVS_READBACK register, but reading it does NOT affect the
               AVS readback fifo pointer. Provided for debug purposes.";

      field {
         sw = r;
         hw = w;
         desc = "The current top-of-fifo AVS slave response sub-frame in the readback fifo";
      } AVS_SLAVE_SUBFRAME[31:0] = 0xffffffff;
   };

   reg AVS_LATEST_SLAVE_SUBFRAME {
      desc = "This register contains the most recently received subframe from the AVS slave, bypassing the
               AVS readback fifo. It is provided so that APB can see the current slave StatusResponse and SlaveAck
               settings in a timely fashion, since the status data from the next entry in the readback fifo might
               have considerable latency relative to when it was initially received from the AVS Slave. ";

      field {
         sw = r;
         hw = w;
         desc = "The most recently received AVS slave response sub-frame";
      } AVS_SLAVE_SUBFRAME[31:0] = 0xffff;
   };


   reg AVS_NORMAL_STATUS {
      desc = "Various Status bits indicating normal operating conditions for APB2AVS bridge block.
               These all have corresponding maskable bits in the AVS_INTERRUPT register";

      field {
         sw = r;
         hw = w;
         desc = "Indicates that the AVS master is issuing a slave resync operation (34 clock cycles of holding mdata high)";
      } AVS_SLAVE_IS_IN_RESYNC[22:22] = 0;

      field {
         sw = r;
         hw = w;
         desc = "Indicates that neither AVS master nor slave is currently driving a transaction on the AVS bus";
      } AVS_BUS_IS_IDLE[21:21] = 0;

      field {
         sw = r;
         hw = w;
         desc = "Indicates AVS_READBACK register has data ready to read on APB";
      } READBACK_HAS_DATA[20:20] = 0;

      field {
         sw = r;
         hw = w;
         desc = "Indicates read-back fifo is full - no new AVS commands will be launched until
                  space is freed by an AVS_READBACK access ";
      } READBACK_FIFO_FULL[19:19] = 0;

      field {
         sw = r;
         hw = w;
         desc = "Indicates AVS_CMD fifo is full - any additional APB writes to AVS_CMD will be dropped until
                  the AVS bus can accept the next command, thus freeing space in the cmd fifo";
      } CMD_FIFO_FULL[18:18] = 0;

      field {
         sw = r;
         hw = w;
         desc = "Indicates AVS_CMD fifo is empty";
      } CMD_FIFO_EMPTY[17:17] = 0;

      field {
         sw = r;
         hw = w;
         desc = "Master is currently in the middle of retrying a failed command";
      } AVS_MASTER_IS_RETRYING[16:16] = 0;

      field {
         sw = r;
         hw = w;
         desc = "Total number of retries attempted by the AVS Master";
      } TOTAL_RETRIES[15:0] = 0;
   };


   reg AVS_SLAVE_STATUS {
      desc = "Contains the most recent status feedback from the AVS slave device";

      field {
         sw = r;
         hw = w;
         desc = "The SlaveAck bits of the most recent slave subframe received: [list]
                     [*]00: Action Performed
                     [*]01:Good CRC received by resource unavailable. No action performed (triggers retry)
                     [*]10: Bad CRC received (triggers retry)
                     [*]11: Good CRC received bit bad data, data type, or selector. No action performed
               [/list]";
      } AVS_SLAVE_ACK[17:16] = 0;

      field {
         sw = r;
         hw = w;
         desc = "The 5-bit Slave StatusResponse of the most recent slave subframe received, indicating the
                  general condition of the slave, per AVS spec StatusReponse field: [list]
                     [*]bit 4: VDone - AND of all VDone bits of active rails
                     [*]bit 3: StatusAlert - Indicates potential status issue, requiring AVSBus Status read cmd for details
                     [*]bit 2: AVS_Control - 1 if ABSBus is controlling at least 1 device output, 0 otherwise.
                     [*]bit 1: MfrSpcfc_Stts1 - Manufacturer-specific
                     [*]bit 0: MfrSpcfc_Stts2 - Manufacturer-specific
                     [/list]";
      } AVS_SLAVE_STATUS_RESPONSE[4:0] = 0;
   };


   reg AVS_FIFOS_STATUS {
      desc = "Contains the number of occupied and vacant slots in the AVS master's command and readback FIFOs";

      field {
         sw = r;
         hw = w;
         desc = "Number of vacant slots in the readback FIFO";
      } READBACK_FIFO_VACANT_SLOTS[27:24] = 8;

      field {
         sw = r;
         hw = w;
         desc = "Number of occupied slots in the readback FIFO";
      } READBACK_FIFO_OCCUPIED_SLOTS[19:16] = 0;

      field {
         sw = r;
         hw = w;
         desc = "Number of vacant slots in the command FIFO";
      } CMD_FIFO_VACANT_SLOTS[11:8] = 8;

      field {
         sw = r;
         hw = w;
         desc = "Number of occupied slots in the command FIFO";
      } CMD_FIFO_OCCUPIED_SLOTS[3:0] = 0;
   };

   reg AVS_INTERRUPT {
      desc = "Interrupt register - A '1' indicates an interrupt has occurred for that bit. To clear the
            interrupt bit, write to the corresponding field in the AVS_INTERRUPT_CLEAR register.";

      field {
         sw = r;
         hw = w;
         desc = "Indicates that the response from AVS slave could not be written to readback FIFO due to it being
                  full => response was dropped";
      } READBACK_OVERFLOW_INT[8:8] = 0;

      field {
         sw = r;
         hw = w;
         desc = "Indicates that an APB read on the AVS_READBACK reg occurred when the readback fifo
                  was empty (AVS_NORMAL_STATUS:readback_has_data=0)";
      } READBACK_UNDERFLOW_INT[7:7] = 0;

      field {
         sw = r;
         hw = w;
         desc = "Indicates that an APB write to AVS_CMD was attempted when the the command fifo was already
                  full - the command is dropped";
      } CMD_FIFO_OVERFLOW_INT[6:6] = 0;

      field {
         sw = r;
         hw = w;
         desc = "Indicates that the AVS Master failed to receive a non-failure acknowledgement from the Slave after a command was retried the maximum allowable number of times (as determined by AVS_CFG_0:max_retries)";
      } MAX_RETRIES_ATTEMPTED_INT[5:5] = 0;

      field {
         sw = r;
         hw = w;
         desc = "Indicates the AVS Slave device is not responding to command subframes from the Master";
      } SLAVE_UNRESPONSIVE_INT[4:4] = 0;

      field {
         sw = r;
         hw = w;
         desc = "Indicates AVS_READBACK register has data ready to read on APB";
      } READBACK_HAS_DATA_INT[3:3] = 0;

      field {
         sw = r;
         hw = w;
         desc = "Indicates read-back fifo is full - no new AVS commands will be launched until
                  space is freed by an AVS_READBACK access ";
      } READBACK_FIFO_FULL_INT[2:2] = 0;

      field {
         sw = r;
         hw = w;
         desc = "Indicates AVS_CMD fifo is full - any additional APB writes to AVS_CMD will be dropped until
                  the AVS bus can accept the next command, thus freeing space in the cmd fifo";
      } CMD_FIFO_FULL_INT[1:1] = 0;

      field {
         sw = r;
         hw = w;
         desc = "Indicates the AVS slave has signaled an interrupt ";
      } AVS_SLAVE_ISSUED_INTERRUPT[0:0] = 0;
   };


   reg AVS_INTERRUPT_MASK {
      desc = "Interrupt mask register - Determines which AVS_INTERRUPT bits can trigger an interrupt";

      field {
         sw = rw;
         hw = r;
         desc = "Disable readback_overflow interrupt";
      } DISABLE_READBACK_OVERFLOW_INT[8:8] = 1;

      field {
         sw = rw;
         hw = r;
         desc = "Disable readback_underflow interrupt";
      } DISABLE_READBACK_UNDERFLOW_INT[7:7] = 1;

      field {
         sw = rw;
         hw = r;
         desc = "Disable cmd_fifo_overflow interrupt";
      } DISABLE_CMD_FIFO_OVERFLOW_INT[6:6] = 1;

      field {
         sw = rw;
         hw = r;
         desc = "Disable max_retries_attempted interrupt";
      } DISABLE_MAX_RETRIES_ATTEMPTED_INT[5:5] = 1;

      field {
         sw = rw;
         hw = r;
         desc = "Disable slave_unresponsive interrupt";
      } DISABLE_SLAVE_UNRESPONSIVE_INT[4:4] = 1;

      field {
         sw = rw;
         hw = r;
         desc = "Disable readback_has_data interrupt";
      } DISABLE_READBACK_HAS_DATA_INT[3:3] = 1;

      field {
         sw = rw;
         hw = r;
         desc = "Disable readback_fifo_full interrupt";
      } DISABLE_READBACK_FIFO_FULL_INT[2:2] = 1;

      field {
         sw = rw;
         hw = r;
         desc = "Disable cmd_fifo_full interrupt";
      } DISABLE_CMD_FIFO_FULL_INT[1:1] = 1;

      field {
         sw = rw;
         hw = r;
         desc = "Disable notification of AVS slave interrupt";
      } DISABLE_AVS_SLAVE_ISSUED_INTERRUPT[0:0] = 1;

   };

   reg AVS_INTERRUPT_CLEAR {
      desc = "Write 1 to clear corresponding interrupt bit";

      field {
         sw = w;
         hw = r;
         singlepulse = true;
         desc = "Clear readback_overflow interrupt";
      } CLEAR_READBACK_OVERFLOW_INT[8:8] = 0;

      field {
         sw = w;
         hw = r;
         singlepulse = true;
         desc = "Clear readback_underflow interrupt";
      } CLEAR_READBACK_UNDERFLOW_INT[7:7] = 0;

      field {
         sw = w;
         hw = r;
         singlepulse = true;
         desc = "Clear cmd_fifo_overflow interrupt";
      } CLEAR_CMD_FIFO_OVERFLOW_INT[6:6] = 0;

      field {
         sw = w;
         hw = r;
         singlepulse = true;
         desc = "Clear max_retries_attempted interrupt";
      } CLEAR_MAX_RETRIES_ATTEMPTED_INT[5:5] = 0;

      field {
         sw = w;
         hw = r;
         singlepulse = true;
         desc = "Clear slave_unresponsive interrupt";
      } CLEAR_SLAVE_UNRESPONSIVE_INT[4:4] = 0;

      field {
         sw = w;
         hw = r;
         singlepulse = true;
         desc = "Clear readback_has_data interrupt";
      } CLEAR_READBACK_HAS_DATA_INT[3:3] = 0;

      field {
         sw = w;
         hw = r;
         singlepulse = true;
         desc = "Clear readback_fifo_full interrupt";
      } CLEAR_READBACK_FIFO_FULL_INT[2:2] = 0;

      field {
         sw = w;
         hw = r;
         singlepulse = true;
         desc = "Clear cmd_fifo_full interrupt";
      } CLEAR_CMD_FIFO_FULL_INT[1:1] = 0;

      field {
         sw = w;
         hw = r;
         singlepulse = true;
         desc = "Clear avs_slave_issued_interrupt ";
      } CLEAR_AVS_SLAVE_ISSUED_INTERRUPT[0:0] = 0;
   };


   reg AVS_CFG_0 {
      desc = "Configuration register for APB2AVS bridge block" ;

      field {
         sw = rw;
         hw = r;
         desc = "Maximum number of times to attempt a retry if an AVS command returns a fail
                  status (either due to targeted resource being busy or CRC failure)";
      } MAX_RETRIES[23:16] = 5;

      field {
         sw = rw;
         hw = r;
         desc = "Max interval to issue slave resync operation on AVS bus, expressed in number of APB clock cycles. NOTE: there is a 3 cycle delay for the resync flag to be seen by the avs controller due to synchronization.";
      } RESYNC_INTERVAL[15:0] = 0x1000;
   };


   reg AVS_CFG_1 {
      desc = "Configuration register for APB2AVS bridge block" ;

      field {
         sw = rw;
         hw = r;
         desc = "Determines the desired duty cycle of the divided clock (when avs_clock_select is set to select the divided APB clock or refclk clock).
                  This value will be divided by 256 to determine the high-pulse percentage of the divided clock period. Depending on the clk_divider_value,
                  it may not be possible to precisely achieve the desired duty cycle - in that case, the closest possible fit is used. If this is set to 0,
                  a value of 1 will be assumed. This is set to 0 by default to trick the clock divider into maintaining the HW-default settings (numerator=0x80)
                  by matching the FF default in the resynced version of the signal.";
      } CLK_DIVIDER_DUTY_CYCLE_NUMERATOR[31:24] = 0;

      field {
         sw = rw;
         hw = r;
         desc = "Determines the divisor value used to generate the AVS clock (when avs_clock_select is set to select the divided APB clock or divided refclk clock).
                  The duty cycle of the divided clock depends both on the clk_divider_value together with the clk_divider_duty_cycle_numerator value. A 50%
                  duty cycle is only possible on even clk_divider_values with clk_divider_duty_cycle_numerator set to 128. This field requires a minimum value of
                  2 - for lower values, 2 will be assumed. This is set to 0 by default to trick the clock divider into maintaining the HW-default settings
                  (divider=0x4) by matching the FF default in the resynced version of the signal.";
      } CLK_DIVIDER_VALUE[23:16] = 0;

      field {
         sw = rw;
         hw = r;
         desc = "Gate off all clocks entering the AVS clock mux - do this before changing the mux selection or changing the clock divider settings, then turn back on afterwards";
      } TURN_OFF_ALL_PREMUX_CLOCKS[10:10] = 0;

      field {
         sw = rw;
         hw = r;
         singlepulse = true;
         desc = "Force master to issue a slave resync (34 clock cycles of holding the mdata signal high) at the next possible opportunity. NOTE: there is a 3 cycle delay for the resync flag to be seen by the avs controller due to synchronization.";
      } FORCE_SLAVE_RESYNC_OPERATION[9:9] = 0;

      field {
         sw = rw;
         hw = r;
         desc = "When the AVS bus is idle, gate the avs_clock from running. Restart it when there are new commands to be run.
                  The master will always first issue 34 slave-resync cycles when the clock first restarts.";
      } STOP_AVS_CLOCK_ON_IDLE[8:8] = 0;

      field {
         sw = rw;
         hw = r;
         desc = "Selects which clock to use for AVS Clock: [list]
                     [*] 00: Use the APB clock directly as the AVS clock
                     [*] 01: Use a divided version of APB clock as the AVS Clock. The clock divider settings are determined by AVS_CFG_1:clk_divider_value and AVS_CFG_1:clk_divider_duty_cycle_numerator
                     [*] 10: Use the refclk clock directly as the AVS clock
                     [*] 11: Use a divided version of refclk clock as the AVS Clock. The clock divider settings are determined by AVS_CFG_1:clk_divider_value and AVS_CFG_1:clk_divider_duty_cycle_numerator
                  [/list]";
      } AVS_CLOCK_SELECT[1:0] = 3;
   };

   reg AVS_CONFIG {
      desc = "AVS Configuration Register";

      field {
         sw = rw;
         hw = r;
         desc = "Enable AVSBus connection to GPIOs. The effective sets OE of the GPIOs dedicated to
                  avs_clock and avs_cdata to 1, sets IE of GPIO dedicated to avs_tdata to 1. By default,
                  this is enabled as the AVSBus state machine immediately starts after reset deassertion.";
      } AVS_GPIO_ENABLE[0:0] = 0x1;
   };

   ////////////////////////////////////////////////////////////////////////////
   // Address Map
   ////////////////////////////////////////////////////////////////////////////

   external    AVS_CMD                                  AVS_CMD                                           @0x0000;
   external    AVS_READBACK                             AVS_READBACK                                      @0x0004;
               AVS_DEBUG_READBACK                       AVS_DEBUG_READBACK                                @0x0008;
               AVS_LATEST_SLAVE_SUBFRAME                AVS_LATEST_SLAVE_SUBFRAME                         @0x000C;
               AVS_NORMAL_STATUS                        AVS_NORMAL_STATUS                                 @0x0020;
               AVS_SLAVE_STATUS                         AVS_SLAVE_STATUS                                  @0x0024;
               AVS_FIFOS_STATUS                         AVS_FIFOS_STATUS                                  @0x0028;
               AVS_INTERRUPT                            AVS_INTERRUPT                                     @0x0030;
               AVS_INTERRUPT_MASK                       AVS_INTERRUPT_MASK                                @0x0034;
               AVS_INTERRUPT_CLEAR                      AVS_INTERRUPT_CLEAR                               @0x0038;
               AVS_CFG_0                                AVS_CFG_0                                         @0x0050;
               AVS_CFG_1                                AVS_CFG_1                                         @0x0054;
               AVS_CONFIG                               AVS_CONFIG                                        @0x0058;

};

`endif
