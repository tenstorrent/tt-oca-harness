// SPDX-License-Identifier: Apache-2.0
// SPDX-FileCopyrightText: 2026 Tenstorrent USA, Inc.

`ifndef TELEMETRY_RECEIVER_RDL
`define TELEMETRY_RECEIVER_RDL

addrmap telemetry_receiver {
    name = "Telemetry Receiver Address Map";
    desc = "Configuration, status, and data-buffer registers for a single telemetry receiver channel.";

    
    //////////////////////////
    // Register Definitions //
    //////////////////////////

    reg CTRL {
        desc = "Control Register";

        field {
            sw = w;
            hw = r;
            singlepulse;
            desc = "Telemetry Receiver Flush. Writing `1` discards all beats queued in the buffer.";
        } TELEMETRY_RX_FLUSH[4:4] = 0x0;

        field {
            sw = rw;
            hw = r;
            hwclr;
            desc = "Telemetry Transmitter Flush. Writing `1` flushes all FIFOs in the telemetry
                    transmitter. The flushing is done via the ATB AF interface. This bit clears
                    itself when the transmitter acknowledges the flush. Writing `0` while a
                    flush is pending withdraws the request, so other fields of this register
                    must be updated with a read-modify-write while the bit is set. The
                    transmitter can finish a flush only while the buffer has space, so firmware
                    must read `TELEMETRY_DATA` while this bit is set.";
        } TELEMETRY_TX_FLUSH[8:8] = 0x0;

        field {
            sw = rw;
            hw = r;
            desc = "Telemetry Buffer Threshold. The Telemetry Buffer Threshold Interrupt is
                    asserted when the number of beats in the buffer is greater than this value.
                    Only values below the buffer depth can assert the interrupt.";
        } BUFFER_THRESHOLD[23:12] = 0x0;
    };

    reg STATUS {
        desc = "Status Register";

        field {
            sw = r;
            hw = w;
            desc = "Telemetry Buffer Empty. Set when the buffer holds no beats.";
        } BUFFER_EMPTY[0:0] = 0x1;

        field {
            sw = r;
            hw = w;
            desc = "Telemetry Buffer Full. Set when the buffer holds the maximum number of beats.";
        } BUFFER_FULL[4:4] = 0x0;
    };

    reg TELEMETRY_DATA {
        desc = "Telemetry Data Register. One read returns `DATA`, `ATID` and `VALID` of the oldest beat
                in the buffer and removes that beat. A read while the buffer is empty returns
                `0x0000_0000` and removes nothing.";

        field {
            sw = r;
            hw = w;
            onread = ruser;
            desc = "ATB Data. Contains `atdata` of the oldest beat in the buffer.";
        } DATA[7:0] = 0x0;

        field {
            sw = r;
            hw = w;
            onread = ruser;
            desc = "ATB ID. Contains `atid` of the oldest beat in the buffer.";
        } ATID[14:8] = 0x0;

        field {
            sw = r;
            hw = w;
            onread = ruser;
            desc = "Beat Valid. Set when the buffer holds a beat, so `DATA` and `ATID` are valid.";
        } VALID[31:31] = 0x0;
    };

    reg INTR_STATUS {
        desc = "Interrupt Status Register";

        field {
            sw = r;
            hw = w;
            desc = "Telemetry Buffer Threshold Interrupt. Asserted when the number of beats in the
                    buffer is greater than
                    `CTRL.BUFFER_THRESHOLD`.";
        } BUFFER_THRESHOLD[4:4] = 0x0;
    };

    reg INTR_ENABLE {
        desc = "Interrupt Enable Register";

        field {
            sw = rw;
            hw = r;
            desc = "Telemetry Buffer Threshold Interrupt Enable.";
        } BUFFER_THRESHOLD[4:4] = 0x0;
    };

    reg INTR_TEST {
        desc = "Interrupt Test Register";

        field {
            sw = rw;
            hw = r;
            desc = "Telemetry Buffer Threshold Interrupt Test. Writing `1` forces the
                    interrupt and writing `0` releases it.";
        } BUFFER_THRESHOLD[4:4] = 0x0;
    };


    /////////////////
    // Address Map //
    /////////////////

    CTRL                      CTRL                                         @0x0;
    STATUS                    STATUS                                       @0x4;
    INTR_STATUS               INTR_STATUS                                  @0x8;
    INTR_ENABLE               INTR_ENABLE                                  @0xC;
    INTR_TEST                 INTR_TEST                                    @0x10;
    external TELEMETRY_DATA   TELEMETRY_DATA                               @0x14;

};

`endif
