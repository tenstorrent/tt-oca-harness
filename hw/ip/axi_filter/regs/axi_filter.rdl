`ifndef FILTER_CTRL_REG_RDL
`define FILTER_CTRL_REG_RDL

addrmap filter_ctrl {
    desc = "Filter control registers. One per filter";

    ////////////////////////////////////////////////////////////////////////////
    // Register Definitions
    ////////////////////////////////////////////////////////////////////////////

    reg FILTER_CONFIG {
        regwidth = 64;
        accesswidth = 64;

        field {
            sw = rw;
            hw = r;
            desc = "Filter range has read permissions";
        } read_en[0:0] = 0x0;

        field {
            sw = rw;
            hw = r;
            desc = "Filter range has write permissions";
        } write_en[1:1] = 0x0;

        field {
            sw = rw;
            hw = r;
            desc = "Address matching mode for the filter. A = 0 means this entry is disabled, A = 1 means this entry is enabled";
        } addr_mode[4:4] = 0x0;

        field {
            sw = rw;
            hw = r;
            desc = "Whether non-secure or secure transactions only can pass through this field";
        } allow_ns[8:8] = 0x0;

        field {
            sw = r;
            hw = w;
            desc = "Data bus width in bytes, encoded as 2^value";
        } data_bus_width[14:12] = 0x3;

        field {
            sw = rw;
            hw = r;
            desc = "Source Id field to match";
        } src_id[19:16] = 0x0;

        field {
            sw = rw;
            hw = r;
            desc = "Group Id field to match";
        } group_id[23:20] = 0x0;

        field {
            sw = rw;
            hw = r;
            desc = "Allow burst transactions through this filter";
        } allow_burst[24:24] = 0x0;

        field {
            sw = rw;
            onwrite=woset;
            hw = r;
            desc = "Write once register to lock filter configurations";
        } locked[63:63] = 0x0;
    };

    reg START_ADDR {
        regwidth = 64;
        accesswidth = 64;
        field {
            sw = rw;
            hw = rw;
            desc = "Start of allowable address range";
        } start_addr[55:0] = 0x0;
    };

    reg END_ADDR {
        regwidth = 64;
        accesswidth = 64;
        field {
            sw = rw;
            hw = rw;
            desc = "End of allowable address range.
                    Defaults to 7 on reset to match the minimum granularity when burst is disabled";
        } end_addr[55:0] = 0x7;
    };

    ////////////////////////////////////////////////////////////////////////////
    // Address Map
    ////////////////////////////////////////////////////////////////////////////

    FILTER_CONFIG            FILTER_CONFIG       @0x0;
    START_ADDR               START_ADDR          @0x8;
    END_ADDR                 END_ADDR            @0x10;
};

`endif