// SPDX-License-Identifier: Apache-2.0
// SPDX-FileCopyrightText: 2026 Tenstorrent USA, Inc.

`ifndef FILTER_CTRL_REG_RDL
`define FILTER_CTRL_REG_RDL

addrmap filter_ctrl {
    desc = "Filter control registers. One per filter";

    ////////////////////////////////////////////////////////////////////////////
    // Register Definitions
    ////////////////////////////////////////////////////////////////////////////

    reg FILTER_CONFIG {
        regwidth = 64;
        accesswidth = 64;

        field {
            sw = rw;
            hw = r;
            desc = "Upon match of transaction to filter fields, whether the transaction has read permissions";
        } read_allowed[0:0] = 0x0;

        field {
            sw = rw;
            hw = r;
            desc = "Upon match of transaction to filter fields, whether the transaction has write permissions";
        } write_allowed[1:1] = 0x0;

        field {
            sw = rw;
            hw = r;
            desc = "Filter entry enabled. A = 0 means this entry is disabled, A = 1 means this entry is enabled and will be used to filter";
        } entry_enabled[4:4] = 0x0;

        field {
            sw = rw;
            hw = r;
            desc = "Secure and Non-secure is categorized as AxPROT[1] in the AXI protocol, where AxPROT[1] == 0 means secure and AxPROT[1] == 1 means Non-secure.
                    Filter entry will match if AxPROT[1] matches the value in this field";
        } allow_ns[8:8] = 0x0;

        field {
            sw = r;
            hw = w;
            desc = "Data bus width in bytes, encoded as 2^value";
        } data_bus_width[14:12] = 0x3;

        field {
            sw = rw;
            hw = r;
            desc = "Source ID field to match. Filter entry will match if the transactions src_id matches the value in this field.
                    A value of 0 in this field is a wildcard: src_id matching is bypassed and the entry matches any src_id.
                    Consequently there is no way to match only transactions whose src_id is 0.";
        } src_id[19:16] = 0x0;

        field {
            sw = rw;
            hw = r;
            desc = "Group ID field to match. Filter entry will match if the transactions group_id matches the value in this field.
                    Note the corner case is the opposite of src_id: the bypass keys off the transaction, not this field.
                    A transaction whose group_id is 0 matches regardless of this field, and a value of 0 here is not a wildcard.
                    Unused for SEP/SMC, where group_id filtering is disabled at build time and this field has no effect";
        } group_id[23:20] = 0x0;

        field {
            sw = rw;
            hw = r;
            desc = "Filter entry will match if this field is 1 or if this field is 0 and the burst len AxLEN is 0.
                    This field also selects the granule of the address range: 4KB when it is 1,
                    2^data_bus_width bytes when it is 0. See start_addr and end_addr for how the range is widened
                    to that granule.";
        } allow_burst[24:24] = 0x0;

        field {
            sw = rw;
            onwrite=woset;
            hw = r;
            desc = "Lock filter configurations. Write once register";
        } locked[63:63] = 0x0;
    };

    reg START_ADDR {
        regwidth = 64;
        accesswidth = 64;
        field {
            sw = rw;
            hw = rw;
            desc = "Start of the allowable address range, rounded down to the base of its granule.
                    The granule is 4KB when allow_burst is 1, and 2^data_bus_width bytes when allow_burst is 0.
                    Address matching ignores the address bits below the granule, so the accepted range always
                    spans whole granules and is never narrower than one: a range shorter than the granule,
                    start_addr == end_addr included, still admits the whole granule, and two granules if it
                    straddles a granule boundary.
                    Hardware writes the rounded start_addr and end_addr back into these fields only when both
                    land in the same granule; otherwise readback returns the programmed values even though
                    matching is still granule-aligned.";
        } start_addr[55:0] = 0x0;
    };

    reg END_ADDR {
        regwidth = 64;
        accesswidth = 64;
        field {
            sw = rw;
            hw = rw;
            desc = "End of the allowable address range, rounded up to the top of its granule.
                    The granule and the write-back behaviour are described under start_addr.
                    Defaults to 7 on reset to match the 8B granule that applies while bursts are disabled.";
        } end_addr[55:0] = 0x7;
    };

    ////////////////////////////////////////////////////////////////////////////
    // Address Map
    ////////////////////////////////////////////////////////////////////////////

    FILTER_CONFIG            FILTER_CONFIG       @0x0;
    START_ADDR               START_ADDR          @0x8;
    END_ADDR                 END_ADDR            @0x10;
};

`endif