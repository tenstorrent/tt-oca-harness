// SPDX-License-Identifier: Apache-2.0
// SPDX-FileCopyrightText: 2026 Tenstorrent USA, Inc.

`ifndef CROSS_TRIGGER_MATRIX_RDL
`define CROSS_TRIGGER_MATRIX_RDL

//------------------------------------------------------------------------------
// Copyright 2025 Tenstorrent Inc.
// Cross Trigger Matrix Configuration Registers
// Generated from template with NUM_CT_SRC = 26, NUM_CT_DST = 26
//------------------------------------------------------------------------------

addrmap cross_trigger_matrix {
    name = "Cross Trigger Matrix Address Map";
    desc = "Configuration registers for the cross trigger matrix";

    // CT_SRC[0] Configuration Register 0 (CT_Dst[31:0])
    reg CT_SRC0_CONFIG_0 {
        desc = "Cross Trigger Source 0 Configuration - Lower 32 CT_Dst ports";
        field {
            sw = rw;
            hw = r;
            desc = "Selects the CT_Dst port(s) to forward on CT_Src[0]. Each bit is mapped to a CT_Dst port (bits [25:0] correspond to CT_Dst[25:0]). Multiple ports may be selected as a trigger source. All selected source ports are then OR'd together to produce CT_Src[0]. Set this register to all-zero to disable the CT_Src[0] output. Bits [31:26] are reserved and should be written as zero.";
        } CT_DST_SELECT[25:0] = 0x0;
        field {
            sw = rw;
            hw = r;
            desc = "Reserved. Must be written as zero.";
        } RESERVED[31:26] = 0x0;
    };


    // CT_SRC[1] Configuration Register 0 (CT_Dst[31:0])
    reg CT_SRC1_CONFIG_0 {
        desc = "Cross Trigger Source 1 Configuration - Lower 32 CT_Dst ports";
        field {
            sw = rw;
            hw = r;
            desc = "Selects the CT_Dst port(s) to forward on CT_Src[1]. Each bit is mapped to a CT_Dst port (bits [25:0] correspond to CT_Dst[25:0]). Multiple ports may be selected as a trigger source. All selected source ports are then OR'd together to produce CT_Src[1]. Set this register to all-zero to disable the CT_Src[1] output. Bits [31:26] are reserved and should be written as zero.";
        } CT_DST_SELECT[25:0] = 0x0;
        field {
            sw = rw;
            hw = r;
            desc = "Reserved. Must be written as zero.";
        } RESERVED[31:26] = 0x0;
    };


    // CT_SRC[2] Configuration Register 0 (CT_Dst[31:0])
    reg CT_SRC2_CONFIG_0 {
        desc = "Cross Trigger Source 2 Configuration - Lower 32 CT_Dst ports";
        field {
            sw = rw;
            hw = r;
            desc = "Selects the CT_Dst port(s) to forward on CT_Src[2]. Each bit is mapped to a CT_Dst port (bits [25:0] correspond to CT_Dst[25:0]). Multiple ports may be selected as a trigger source. All selected source ports are then OR'd together to produce CT_Src[2]. Set this register to all-zero to disable the CT_Src[2] output. Bits [31:26] are reserved and should be written as zero.";
        } CT_DST_SELECT[25:0] = 0x0;
        field {
            sw = rw;
            hw = r;
            desc = "Reserved. Must be written as zero.";
        } RESERVED[31:26] = 0x0;
    };


    // CT_SRC[3] Configuration Register 0 (CT_Dst[31:0])
    reg CT_SRC3_CONFIG_0 {
        desc = "Cross Trigger Source 3 Configuration - Lower 32 CT_Dst ports";
        field {
            sw = rw;
            hw = r;
            desc = "Selects the CT_Dst port(s) to forward on CT_Src[3]. Each bit is mapped to a CT_Dst port (bits [25:0] correspond to CT_Dst[25:0]). Multiple ports may be selected as a trigger source. All selected source ports are then OR'd together to produce CT_Src[3]. Set this register to all-zero to disable the CT_Src[3] output. Bits [31:26] are reserved and should be written as zero.";
        } CT_DST_SELECT[25:0] = 0x0;
        field {
            sw = rw;
            hw = r;
            desc = "Reserved. Must be written as zero.";
        } RESERVED[31:26] = 0x0;
    };


    // CT_SRC[4] Configuration Register 0 (CT_Dst[31:0])
    reg CT_SRC4_CONFIG_0 {
        desc = "Cross Trigger Source 4 Configuration - Lower 32 CT_Dst ports";
        field {
            sw = rw;
            hw = r;
            desc = "Selects the CT_Dst port(s) to forward on CT_Src[4]. Each bit is mapped to a CT_Dst port (bits [25:0] correspond to CT_Dst[25:0]). Multiple ports may be selected as a trigger source. All selected source ports are then OR'd together to produce CT_Src[4]. Set this register to all-zero to disable the CT_Src[4] output. Bits [31:26] are reserved and should be written as zero.";
        } CT_DST_SELECT[25:0] = 0x0;
        field {
            sw = rw;
            hw = r;
            desc = "Reserved. Must be written as zero.";
        } RESERVED[31:26] = 0x0;
    };


    // CT_SRC[5] Configuration Register 0 (CT_Dst[31:0])
    reg CT_SRC5_CONFIG_0 {
        desc = "Cross Trigger Source 5 Configuration - Lower 32 CT_Dst ports";
        field {
            sw = rw;
            hw = r;
            desc = "Selects the CT_Dst port(s) to forward on CT_Src[5]. Each bit is mapped to a CT_Dst port (bits [25:0] correspond to CT_Dst[25:0]). Multiple ports may be selected as a trigger source. All selected source ports are then OR'd together to produce CT_Src[5]. Set this register to all-zero to disable the CT_Src[5] output. Bits [31:26] are reserved and should be written as zero.";
        } CT_DST_SELECT[25:0] = 0x0;
        field {
            sw = rw;
            hw = r;
            desc = "Reserved. Must be written as zero.";
        } RESERVED[31:26] = 0x0;
    };


    // CT_SRC[6] Configuration Register 0 (CT_Dst[31:0])
    reg CT_SRC6_CONFIG_0 {
        desc = "Cross Trigger Source 6 Configuration - Lower 32 CT_Dst ports";
        field {
            sw = rw;
            hw = r;
            desc = "Selects the CT_Dst port(s) to forward on CT_Src[6]. Each bit is mapped to a CT_Dst port (bits [25:0] correspond to CT_Dst[25:0]). Multiple ports may be selected as a trigger source. All selected source ports are then OR'd together to produce CT_Src[6]. Set this register to all-zero to disable the CT_Src[6] output. Bits [31:26] are reserved and should be written as zero.";
        } CT_DST_SELECT[25:0] = 0x0;
        field {
            sw = rw;
            hw = r;
            desc = "Reserved. Must be written as zero.";
        } RESERVED[31:26] = 0x0;
    };


    // CT_SRC[7] Configuration Register 0 (CT_Dst[31:0])
    reg CT_SRC7_CONFIG_0 {
        desc = "Cross Trigger Source 7 Configuration - Lower 32 CT_Dst ports";
        field {
            sw = rw;
            hw = r;
            desc = "Selects the CT_Dst port(s) to forward on CT_Src[7]. Each bit is mapped to a CT_Dst port (bits [25:0] correspond to CT_Dst[25:0]). Multiple ports may be selected as a trigger source. All selected source ports are then OR'd together to produce CT_Src[7]. Set this register to all-zero to disable the CT_Src[7] output. Bits [31:26] are reserved and should be written as zero.";
        } CT_DST_SELECT[25:0] = 0x0;
        field {
            sw = rw;
            hw = r;
            desc = "Reserved. Must be written as zero.";
        } RESERVED[31:26] = 0x0;
    };


    // CT_SRC[8] Configuration Register 0 (CT_Dst[31:0])
    reg CT_SRC8_CONFIG_0 {
        desc = "Cross Trigger Source 8 Configuration - Lower 32 CT_Dst ports";
        field {
            sw = rw;
            hw = r;
            desc = "Selects the CT_Dst port(s) to forward on CT_Src[8]. Each bit is mapped to a CT_Dst port (bits [25:0] correspond to CT_Dst[25:0]). Multiple ports may be selected as a trigger source. All selected source ports are then OR'd together to produce CT_Src[8]. Set this register to all-zero to disable the CT_Src[8] output. Bits [31:26] are reserved and should be written as zero.";
        } CT_DST_SELECT[25:0] = 0x0;
        field {
            sw = rw;
            hw = r;
            desc = "Reserved. Must be written as zero.";
        } RESERVED[31:26] = 0x0;
    };


    // CT_SRC[9] Configuration Register 0 (CT_Dst[31:0])
    reg CT_SRC9_CONFIG_0 {
        desc = "Cross Trigger Source 9 Configuration - Lower 32 CT_Dst ports";
        field {
            sw = rw;
            hw = r;
            desc = "Selects the CT_Dst port(s) to forward on CT_Src[9]. Each bit is mapped to a CT_Dst port (bits [25:0] correspond to CT_Dst[25:0]). Multiple ports may be selected as a trigger source. All selected source ports are then OR'd together to produce CT_Src[9]. Set this register to all-zero to disable the CT_Src[9] output. Bits [31:26] are reserved and should be written as zero.";
        } CT_DST_SELECT[25:0] = 0x0;
        field {
            sw = rw;
            hw = r;
            desc = "Reserved. Must be written as zero.";
        } RESERVED[31:26] = 0x0;
    };


    // CT_SRC[10] Configuration Register 0 (CT_Dst[31:0])
    reg CT_SRC10_CONFIG_0 {
        desc = "Cross Trigger Source 10 Configuration - Lower 32 CT_Dst ports";
        field {
            sw = rw;
            hw = r;
            desc = "Selects the CT_Dst port(s) to forward on CT_Src[10]. Each bit is mapped to a CT_Dst port (bits [25:0] correspond to CT_Dst[25:0]). Multiple ports may be selected as a trigger source. All selected source ports are then OR'd together to produce CT_Src[10]. Set this register to all-zero to disable the CT_Src[10] output. Bits [31:26] are reserved and should be written as zero.";
        } CT_DST_SELECT[25:0] = 0x0;
        field {
            sw = rw;
            hw = r;
            desc = "Reserved. Must be written as zero.";
        } RESERVED[31:26] = 0x0;
    };


    // CT_SRC[11] Configuration Register 0 (CT_Dst[31:0])
    reg CT_SRC11_CONFIG_0 {
        desc = "Cross Trigger Source 11 Configuration - Lower 32 CT_Dst ports";
        field {
            sw = rw;
            hw = r;
            desc = "Selects the CT_Dst port(s) to forward on CT_Src[11]. Each bit is mapped to a CT_Dst port (bits [25:0] correspond to CT_Dst[25:0]). Multiple ports may be selected as a trigger source. All selected source ports are then OR'd together to produce CT_Src[11]. Set this register to all-zero to disable the CT_Src[11] output. Bits [31:26] are reserved and should be written as zero.";
        } CT_DST_SELECT[25:0] = 0x0;
        field {
            sw = rw;
            hw = r;
            desc = "Reserved. Must be written as zero.";
        } RESERVED[31:26] = 0x0;
    };


    // CT_SRC[12] Configuration Register 0 (CT_Dst[31:0])
    reg CT_SRC12_CONFIG_0 {
        desc = "Cross Trigger Source 12 Configuration - Lower 32 CT_Dst ports";
        field {
            sw = rw;
            hw = r;
            desc = "Selects the CT_Dst port(s) to forward on CT_Src[12]. Each bit is mapped to a CT_Dst port (bits [25:0] correspond to CT_Dst[25:0]). Multiple ports may be selected as a trigger source. All selected source ports are then OR'd together to produce CT_Src[12]. Set this register to all-zero to disable the CT_Src[12] output. Bits [31:26] are reserved and should be written as zero.";
        } CT_DST_SELECT[25:0] = 0x0;
        field {
            sw = rw;
            hw = r;
            desc = "Reserved. Must be written as zero.";
        } RESERVED[31:26] = 0x0;
    };


    // CT_SRC[13] Configuration Register 0 (CT_Dst[31:0])
    reg CT_SRC13_CONFIG_0 {
        desc = "Cross Trigger Source 13 Configuration - Lower 32 CT_Dst ports";
        field {
            sw = rw;
            hw = r;
            desc = "Selects the CT_Dst port(s) to forward on CT_Src[13]. Each bit is mapped to a CT_Dst port (bits [25:0] correspond to CT_Dst[25:0]). Multiple ports may be selected as a trigger source. All selected source ports are then OR'd together to produce CT_Src[13]. Set this register to all-zero to disable the CT_Src[13] output. Bits [31:26] are reserved and should be written as zero.";
        } CT_DST_SELECT[25:0] = 0x0;
        field {
            sw = rw;
            hw = r;
            desc = "Reserved. Must be written as zero.";
        } RESERVED[31:26] = 0x0;
    };


    // CT_SRC[14] Configuration Register 0 (CT_Dst[31:0])
    reg CT_SRC14_CONFIG_0 {
        desc = "Cross Trigger Source 14 Configuration - Lower 32 CT_Dst ports";
        field {
            sw = rw;
            hw = r;
            desc = "Selects the CT_Dst port(s) to forward on CT_Src[14]. Each bit is mapped to a CT_Dst port (bits [25:0] correspond to CT_Dst[25:0]). Multiple ports may be selected as a trigger source. All selected source ports are then OR'd together to produce CT_Src[14]. Set this register to all-zero to disable the CT_Src[14] output. Bits [31:26] are reserved and should be written as zero.";
        } CT_DST_SELECT[25:0] = 0x0;
        field {
            sw = rw;
            hw = r;
            desc = "Reserved. Must be written as zero.";
        } RESERVED[31:26] = 0x0;
    };


    // CT_SRC[15] Configuration Register 0 (CT_Dst[31:0])
    reg CT_SRC15_CONFIG_0 {
        desc = "Cross Trigger Source 15 Configuration - Lower 32 CT_Dst ports";
        field {
            sw = rw;
            hw = r;
            desc = "Selects the CT_Dst port(s) to forward on CT_Src[15]. Each bit is mapped to a CT_Dst port (bits [25:0] correspond to CT_Dst[25:0]). Multiple ports may be selected as a trigger source. All selected source ports are then OR'd together to produce CT_Src[15]. Set this register to all-zero to disable the CT_Src[15] output. Bits [31:26] are reserved and should be written as zero.";
        } CT_DST_SELECT[25:0] = 0x0;
        field {
            sw = rw;
            hw = r;
            desc = "Reserved. Must be written as zero.";
        } RESERVED[31:26] = 0x0;
    };


    // CT_SRC[16] Configuration Register 0 (CT_Dst[31:0])
    reg CT_SRC16_CONFIG_0 {
        desc = "Cross Trigger Source 16 Configuration - Lower 32 CT_Dst ports";
        field {
            sw = rw;
            hw = r;
            desc = "Selects the CT_Dst port(s) to forward on CT_Src[16]. Each bit is mapped to a CT_Dst port (bits [25:0] correspond to CT_Dst[25:0]). Multiple ports may be selected as a trigger source. All selected source ports are then OR'd together to produce CT_Src[16]. Set this register to all-zero to disable the CT_Src[16] output. Bits [31:26] are reserved and should be written as zero.";
        } CT_DST_SELECT[25:0] = 0x0;
        field {
            sw = rw;
            hw = r;
            desc = "Reserved. Must be written as zero.";
        } RESERVED[31:26] = 0x0;
    };


    // CT_SRC[17] Configuration Register 0 (CT_Dst[31:0])
    reg CT_SRC17_CONFIG_0 {
        desc = "Cross Trigger Source 17 Configuration - Lower 32 CT_Dst ports";
        field {
            sw = rw;
            hw = r;
            desc = "Selects the CT_Dst port(s) to forward on CT_Src[17]. Each bit is mapped to a CT_Dst port (bits [25:0] correspond to CT_Dst[25:0]). Multiple ports may be selected as a trigger source. All selected source ports are then OR'd together to produce CT_Src[17]. Set this register to all-zero to disable the CT_Src[17] output. Bits [31:26] are reserved and should be written as zero.";
        } CT_DST_SELECT[25:0] = 0x0;
        field {
            sw = rw;
            hw = r;
            desc = "Reserved. Must be written as zero.";
        } RESERVED[31:26] = 0x0;
    };


    // CT_SRC[18] Configuration Register 0 (CT_Dst[31:0])
    reg CT_SRC18_CONFIG_0 {
        desc = "Cross Trigger Source 18 Configuration - Lower 32 CT_Dst ports";
        field {
            sw = rw;
            hw = r;
            desc = "Selects the CT_Dst port(s) to forward on CT_Src[18]. Each bit is mapped to a CT_Dst port (bits [25:0] correspond to CT_Dst[25:0]). Multiple ports may be selected as a trigger source. All selected source ports are then OR'd together to produce CT_Src[18]. Set this register to all-zero to disable the CT_Src[18] output. Bits [31:26] are reserved and should be written as zero.";
        } CT_DST_SELECT[25:0] = 0x0;
        field {
            sw = rw;
            hw = r;
            desc = "Reserved. Must be written as zero.";
        } RESERVED[31:26] = 0x0;
    };


    // CT_SRC[19] Configuration Register 0 (CT_Dst[31:0])
    reg CT_SRC19_CONFIG_0 {
        desc = "Cross Trigger Source 19 Configuration - Lower 32 CT_Dst ports";
        field {
            sw = rw;
            hw = r;
            desc = "Selects the CT_Dst port(s) to forward on CT_Src[19]. Each bit is mapped to a CT_Dst port (bits [25:0] correspond to CT_Dst[25:0]). Multiple ports may be selected as a trigger source. All selected source ports are then OR'd together to produce CT_Src[19]. Set this register to all-zero to disable the CT_Src[19] output. Bits [31:26] are reserved and should be written as zero.";
        } CT_DST_SELECT[25:0] = 0x0;
        field {
            sw = rw;
            hw = r;
            desc = "Reserved. Must be written as zero.";
        } RESERVED[31:26] = 0x0;
    };


    // CT_SRC[20] Configuration Register 0 (CT_Dst[31:0])
    reg CT_SRC20_CONFIG_0 {
        desc = "Cross Trigger Source 20 Configuration - Lower 32 CT_Dst ports";
        field {
            sw = rw;
            hw = r;
            desc = "Selects the CT_Dst port(s) to forward on CT_Src[20]. Each bit is mapped to a CT_Dst port (bits [25:0] correspond to CT_Dst[25:0]). Multiple ports may be selected as a trigger source. All selected source ports are then OR'd together to produce CT_Src[20]. Set this register to all-zero to disable the CT_Src[20] output. Bits [31:26] are reserved and should be written as zero.";
        } CT_DST_SELECT[25:0] = 0x0;
        field {
            sw = rw;
            hw = r;
            desc = "Reserved. Must be written as zero.";
        } RESERVED[31:26] = 0x0;
    };


    // CT_SRC[21] Configuration Register 0 (CT_Dst[31:0])
    reg CT_SRC21_CONFIG_0 {
        desc = "Cross Trigger Source 21 Configuration - Lower 32 CT_Dst ports";
        field {
            sw = rw;
            hw = r;
            desc = "Selects the CT_Dst port(s) to forward on CT_Src[21]. Each bit is mapped to a CT_Dst port (bits [25:0] correspond to CT_Dst[25:0]). Multiple ports may be selected as a trigger source. All selected source ports are then OR'd together to produce CT_Src[21]. Set this register to all-zero to disable the CT_Src[21] output. Bits [31:26] are reserved and should be written as zero.";
        } CT_DST_SELECT[25:0] = 0x0;
        field {
            sw = rw;
            hw = r;
            desc = "Reserved. Must be written as zero.";
        } RESERVED[31:26] = 0x0;
    };


    // CT_SRC[22] Configuration Register 0 (CT_Dst[31:0])
    reg CT_SRC22_CONFIG_0 {
        desc = "Cross Trigger Source 22 Configuration - Lower 32 CT_Dst ports";
        field {
            sw = rw;
            hw = r;
            desc = "Selects the CT_Dst port(s) to forward on CT_Src[22]. Each bit is mapped to a CT_Dst port (bits [25:0] correspond to CT_Dst[25:0]). Multiple ports may be selected as a trigger source. All selected source ports are then OR'd together to produce CT_Src[22]. Set this register to all-zero to disable the CT_Src[22] output. Bits [31:26] are reserved and should be written as zero.";
        } CT_DST_SELECT[25:0] = 0x0;
        field {
            sw = rw;
            hw = r;
            desc = "Reserved. Must be written as zero.";
        } RESERVED[31:26] = 0x0;
    };


    // CT_SRC[23] Configuration Register 0 (CT_Dst[31:0])
    reg CT_SRC23_CONFIG_0 {
        desc = "Cross Trigger Source 23 Configuration - Lower 32 CT_Dst ports";
        field {
            sw = rw;
            hw = r;
            desc = "Selects the CT_Dst port(s) to forward on CT_Src[23]. Each bit is mapped to a CT_Dst port (bits [25:0] correspond to CT_Dst[25:0]). Multiple ports may be selected as a trigger source. All selected source ports are then OR'd together to produce CT_Src[23]. Set this register to all-zero to disable the CT_Src[23] output. Bits [31:26] are reserved and should be written as zero.";
        } CT_DST_SELECT[25:0] = 0x0;
        field {
            sw = rw;
            hw = r;
            desc = "Reserved. Must be written as zero.";
        } RESERVED[31:26] = 0x0;
    };


    // CT_SRC[24] Configuration Register 0 (CT_Dst[31:0])
    reg CT_SRC24_CONFIG_0 {
        desc = "Cross Trigger Source 24 Configuration - Lower 32 CT_Dst ports";
        field {
            sw = rw;
            hw = r;
            desc = "Selects the CT_Dst port(s) to forward on CT_Src[24]. Each bit is mapped to a CT_Dst port (bits [25:0] correspond to CT_Dst[25:0]). Multiple ports may be selected as a trigger source. All selected source ports are then OR'd together to produce CT_Src[24]. Set this register to all-zero to disable the CT_Src[24] output. Bits [31:26] are reserved and should be written as zero.";
        } CT_DST_SELECT[25:0] = 0x0;
        field {
            sw = rw;
            hw = r;
            desc = "Reserved. Must be written as zero.";
        } RESERVED[31:26] = 0x0;
    };


    // CT_SRC[25] Configuration Register 0 (CT_Dst[31:0])
    reg CT_SRC25_CONFIG_0 {
        desc = "Cross Trigger Source 25 Configuration - Lower 32 CT_Dst ports";
        field {
            sw = rw;
            hw = r;
            desc = "Selects the CT_Dst port(s) to forward on CT_Src[25]. Each bit is mapped to a CT_Dst port (bits [25:0] correspond to CT_Dst[25:0]). Multiple ports may be selected as a trigger source. All selected source ports are then OR'd together to produce CT_Src[25]. Set this register to all-zero to disable the CT_Src[25] output. Bits [31:26] are reserved and should be written as zero.";
        } CT_DST_SELECT[25:0] = 0x0;
        field {
            sw = rw;
            hw = r;
            desc = "Reserved. Must be written as zero.";
        } RESERVED[31:26] = 0x0;
    };


    // Register address map - each CT_SRC uses 8 bytes (two 4-byte registers)
    CT_SRC0_CONFIG_0  CT_SRC0_CONFIG_0  @0x0;
    CT_SRC1_CONFIG_0  CT_SRC1_CONFIG_0  @0x8;
    CT_SRC2_CONFIG_0  CT_SRC2_CONFIG_0  @0x10;
    CT_SRC3_CONFIG_0  CT_SRC3_CONFIG_0  @0x18;
    CT_SRC4_CONFIG_0  CT_SRC4_CONFIG_0  @0x20;
    CT_SRC5_CONFIG_0  CT_SRC5_CONFIG_0  @0x28;
    CT_SRC6_CONFIG_0  CT_SRC6_CONFIG_0  @0x30;
    CT_SRC7_CONFIG_0  CT_SRC7_CONFIG_0  @0x38;
    CT_SRC8_CONFIG_0  CT_SRC8_CONFIG_0  @0x40;
    CT_SRC9_CONFIG_0  CT_SRC9_CONFIG_0  @0x48;
    CT_SRC10_CONFIG_0  CT_SRC10_CONFIG_0  @0x50;
    CT_SRC11_CONFIG_0  CT_SRC11_CONFIG_0  @0x58;
    CT_SRC12_CONFIG_0  CT_SRC12_CONFIG_0  @0x60;
    CT_SRC13_CONFIG_0  CT_SRC13_CONFIG_0  @0x68;
    CT_SRC14_CONFIG_0  CT_SRC14_CONFIG_0  @0x70;
    CT_SRC15_CONFIG_0  CT_SRC15_CONFIG_0  @0x78;
    CT_SRC16_CONFIG_0  CT_SRC16_CONFIG_0  @0x80;
    CT_SRC17_CONFIG_0  CT_SRC17_CONFIG_0  @0x88;
    CT_SRC18_CONFIG_0  CT_SRC18_CONFIG_0  @0x90;
    CT_SRC19_CONFIG_0  CT_SRC19_CONFIG_0  @0x98;
    CT_SRC20_CONFIG_0  CT_SRC20_CONFIG_0  @0xa0;
    CT_SRC21_CONFIG_0  CT_SRC21_CONFIG_0  @0xa8;
    CT_SRC22_CONFIG_0  CT_SRC22_CONFIG_0  @0xb0;
    CT_SRC23_CONFIG_0  CT_SRC23_CONFIG_0  @0xb8;
    CT_SRC24_CONFIG_0  CT_SRC24_CONFIG_0  @0xc0;
    CT_SRC25_CONFIG_0  CT_SRC25_CONFIG_0  @0xc8;
};

`endif
