// SPDX-License-Identifier: Apache-2.0
// SPDX-FileCopyrightText: 2026 Tenstorrent USA, Inc.

// Key Manager Mailbox - SEP Side Interface
// SystemRDL 2.0 Register Definition
//
// Copyright 2026 Tenstorrent Inc.
//
// Base Address: Defined in SEP register map (not in KM address space)
// Size: 4KB decode window (0x1000); registers occupy lower portion
// This register file is accessed by SEP host to interact with the mailbox

addrmap km_mailbox_sep {
    name = "Key Manager Mailbox SEP Side";
    desc = "Register interface for SEP host to access mailbox (write to inbound FIFO, read from outbound FIFO)";

    default regwidth = 32;
    default sw = rw;
    default hw = r;

    //=========================================================================
    // WRITE_DATA Register (0x000)
    //=========================================================================
    reg write_data_reg {
        name = "WRITE_DATA";
        desc = "Write data to inbound FIFO (SEP→KM messages)";

        field {
            name = "DATA";
            desc = "32-bit data word to write to inbound FIFO";
            sw = w;
            hw = r;
            reset = 32'h0;
        } data[31:0];
    };

    write_data_reg SEP_WRITE_DATA @ 0x000;

    //=========================================================================
    // WRITE_SEPARATOR Register (0x004)
    //=========================================================================
    reg write_separator_reg {
        name = "WRITE_SEPARATOR";
        desc = "Write 1 to set message separator on next inbound (SEP→KM) write. Cleared by hardware when that write completes.";

        field {
            name = "SET";
            desc = "Write 1 to set message separator on next inbound write. Cleared by hardware when that write completes.";
            sw = rw;
            hw = rw;
            reset = 1'b0;
        } set[0:0];

        field {
            name = "RSVD";
            desc = "Reserved";
            sw = r;
            hw = na;
            reset = 31'h0;
        } rsvd[31:1];
    };

    write_separator_reg SEP_WRITE_SEPARATOR @ 0x004;

    //=========================================================================
    // READ_DATA Register (0x008)
    //=========================================================================
    reg read_data_reg {
        name = "READ_DATA";
        desc = "Read data from outbound FIFO (KM→SEP messages)";

        field {
            name = "DATA";
            desc = "32-bit data word read from outbound FIFO";
            sw = r;
            hw = r;
            reset = 32'h0;
        } data[31:0];
    };

    read_data_reg SEP_READ_DATA @ 0x008;

    //=========================================================================
    // STATUS Register (0x00C)
    //=========================================================================
    reg status_reg {
        name = "STATUS";
        desc = "FIFO status information";

        field {
            name = "INBOUND_EMPTY";
            desc = "Inbound FIFO is empty (no data available for KM to read)";
            sw = r;
            hw = w;
            reset = 1'b1;
        } inbound_empty[0:0];

        field {
            name = "INBOUND_FULL";
            desc = "Inbound FIFO is full (cannot write more data)";
            sw = r;
            hw = w;
            reset = 1'b0;
        } inbound_full[1:1];

        field {
            name = "OUTBOUND_EMPTY";
            desc = "Outbound FIFO is empty (no data available for SEP to read)";
            sw = r;
            hw = w;
            reset = 1'b1;
        } outbound_empty[2:2];

        field {
            name = "OUTBOUND_FULL";
            desc = "Outbound FIFO is full";
            sw = r;
            hw = w;
            reset = 1'b0;
        } outbound_full[3:3];

        field {
            name = "INBOUND_DEPTH";
            desc = "Inbound FIFO fill level (number of words in FIFO)";
            sw = r;
            hw = w;
            reset = 8'h0;
        } inbound_depth[11:4];

        field {
            name = "OUTBOUND_DEPTH";
            desc = "Outbound FIFO fill level (number of words in FIFO)";
            sw = r;
            hw = w;
            reset = 8'h0;
        } outbound_depth[19:12];

        field {
            name = "INBOUND_OVERFLOW";
            desc = "Inbound FIFO overflow detected (write attempted when full). Sticky, write 1 to clear.";
            sw = rw;
            hw = rw;
            hwset = true;
            stickybit = true;
            onwrite = woclr;
            reset = 1'b0;
        } inbound_overflow[20:20];

        field {
            name = "OUTBOUND_OVERFLOW";
            desc = "Outbound FIFO overflow detected (write attempted when full). Sticky, write 1 to clear.";
            sw = rw;
            hw = rw;
            hwset = true;
            stickybit = true;
            onwrite = woclr;
            reset = 1'b0;
        } outbound_overflow[21:21];

        field {
            name = "INBOUND_UNDERFLOW";
            desc = "Inbound FIFO underflow detected (read attempted when empty). Sticky, write 1 to clear.";
            sw = rw;
            hw = rw;
            hwset = true;
            stickybit = true;
            onwrite = woclr;
            reset = 1'b0;
        } inbound_underflow[22:22];

        field {
            name = "OUTBOUND_UNDERFLOW";
            desc = "Outbound FIFO underflow detected (read attempted when empty). Sticky, write 1 to clear.";
            sw = rw;
            hw = rw;
            hwset = true;
            stickybit = true;
            onwrite = woclr;
            reset = 1'b0;
        } outbound_underflow[23:23];

        field {
            name = "INBOUND_SEPARATOR";
            desc = "Message separator: 1 if the last word read from inbound FIFO had the separator bit set (last word of message). Read-only, not sticky.";
            sw = r;
            hw = w;
            reset = 1'b0;
        } inbound_separator[24:24];

        field {
            name = "OUTBOUND_SEPARATOR";
            desc = "Message separator: 1 if the last word read from outbound FIFO had the separator bit set (last word of message). Read-only, not sticky.";
            sw = r;
            hw = w;
            reset = 1'b0;
        } outbound_separator[25:25];

        field {
            name = "RSVD";
            desc = "Reserved";
            sw = r;
            hw = na;
            reset = 6'h0;
        } rsvd[31:26];
    };

    status_reg SEP_STATUS @ 0x00C;

    //=========================================================================
    // IRQ_STATUS Register (0x010)
    //=========================================================================
    reg irq_status_reg {
        name = "IRQ_STATUS";
        desc = "Interrupt status register";

        field {
            name = "OUTBOUND_READ_DATA_AVAIL";
            desc = "Outbound FIFO has data available for SEP to read (level-sensitive). 1 = data available, 0 = empty.";
            sw = r;
            hw = w;
            reset = 1'b0;
        } outbound_read_data_avail[0:0];

        field {
            name = "INBOUND_WRITE_SPACE_AVAIL";
            desc = "Inbound FIFO has space available for SEP to write (level-sensitive). 1 = space available, 0 = full.";
            sw = r;
            hw = w;
            reset = 1'b0;
        } inbound_write_space_avail[1:1];

        field {
            name = "INBOUND_OVERFLOW";
            desc = "Inbound FIFO overflow detected. Sticky, write 1 to clear.";
            sw = rw;
            hw = rw;
            hwset = true;
            stickybit = true;
            onwrite = woclr;
            reset = 1'b0;
        } inbound_overflow[2:2];

        field {
            name = "OUTBOUND_UNDERFLOW";
            desc = "Outbound FIFO underflow detected. Sticky, write 1 to clear.";
            sw = rw;
            hw = rw;
            hwset = true;
            stickybit = true;
            onwrite = woclr;
            reset = 1'b0;
        } outbound_underflow[3:3];

        field {
            name = "FLUSHED_BY_KM";
            desc = "KM performed a mailbox flush. Sticky, write 1 to clear.";
            sw = rw;
            hw = rw;
            hwset = true;
            stickybit = true;
            onwrite = woclr;
            reset = 1'b0;
        } flushed_by_km[4:4];

        field {
            name = "RSVD";
            desc = "Reserved";
            sw = r;
            hw = na;
            reset = 27'h0;
        } rsvd[31:5];
    };

    irq_status_reg SEP_IRQ_STATUS @ 0x010;

    //=========================================================================
    // IRQ_ENABLE Register (0x014)
    //=========================================================================
    reg irq_enable_reg {
        name = "IRQ_ENABLE";
        desc = "Interrupt enable register for SEP host";

        field {
            name = "OUTBOUND_READ_DATA_AVAIL_EN";
            desc = "Enable interrupt to SEP when outbound FIFO has data available (KM->SEP messages)";
            sw = rw;
            hw = r;
            reset = 1'b0;
        } outbound_read_data_avail_en[0:0];

        field {
            name = "INBOUND_WRITE_SPACE_AVAIL_EN";
            desc = "Enable interrupt to SEP when inbound FIFO has space available (SEP->KM messages)";
            sw = rw;
            hw = r;
            reset = 1'b0;
        } inbound_write_space_avail_en[1:1];

        field {
            name = "INBOUND_OVERFLOW_EN";
            desc = "Enable interrupt to SEP when inbound FIFO overflow is detected";
            sw = rw;
            hw = r;
            reset = 1'b0;
        } inbound_overflow_en[2:2];

        field {
            name = "OUTBOUND_UNDERFLOW_EN";
            desc = "Enable interrupt to SEP when outbound FIFO underflow is detected";
            sw = rw;
            hw = r;
            reset = 1'b0;
        } outbound_underflow_en[3:3];

        field {
            name = "FLUSHED_BY_KM_EN";
            desc = "Enable interrupt to SEP when KM performs a mailbox flush";
            sw = rw;
            hw = r;
            reset = 1'b0;
        } flushed_by_km_en[4:4];

        field {
            name = "RSVD";
            desc = "Reserved";
            sw = r;
            hw = na;
            reset = 27'h0;
        } rsvd[31:5];
    };

    irq_enable_reg SEP_IRQ_ENABLE @ 0x014;

    //=========================================================================
    // CTRL Register (0x018)
    //=========================================================================
    reg ctrl_reg {
        name = "CTRL";
        desc = "Control register for mailbox behavior configuration";

        field {
            name = "INBOUND_OVERFLOW_RESP";
            desc = "Response type for inbound FIFO overflow: 0=SLVERR (default), 1=OKAY";
            sw = rw;
            hw = r;
            reset = 1'b0;
        } inbound_overflow_resp[0:0];

        field {
            name = "OUTBOUND_UNDERFLOW_RESP";
            desc = "Response type for outbound FIFO underflow: 0=SLVERR (default), 1=OKAY";
            sw = rw;
            hw = r;
            reset = 1'b0;
        } outbound_underflow_resp[1:1];

        field {
            name = "FLUSH";
            desc = "Write 1 to flush all mailbox FIFOs (inbound and outbound). Cleared by hardware when flush completes.";
            sw = rw;
            hw = rw;
            reset = 1'b0;
        } flush[2:2];

        field {
            name = "RSVD";
            desc = "Reserved";
            sw = r;
            hw = na;
            reset = 29'h0;
        } rsvd[31:3];
    };

    ctrl_reg SEP_CTRL @ 0x018;
};
