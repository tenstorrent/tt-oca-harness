// SPDX-License-Identifier: Apache-2.0
// SPDX-FileCopyrightText: 2026 Tenstorrent USA, Inc.

`ifndef UART_LOG_ENGINE_CTRL_RDL
`define UART_LOG_ENGINE_CTRL_RDL

addrmap uart_log_engine_ctrl {
    name = "UART Log Engine Control Address Map";
    desc = "Top-level enable register for the UART log-engine block.";

    //////////////////////////
    // Register Definitions //
    //////////////////////////

    reg CTRL {
        desc = "Control Register";

        field {
            sw = rw;
            hw = r;
            desc = "UART Enable. The hardware LSIO request of the UART's RX, TX, RTS and CTS
                    pads: while set, the UART owns their data and direction. While clear, the UART
                    keeps running, but its pads follow the GPIO data and direction selection like
                    any pad without a hardware request, so TX and RTS do not reach the pins unless
                    software forces LSIO selection.";
        } UART_EN[0:0] = 0x0;
    };


    /////////////////
    // Address Map //
    /////////////////

    CTRL    CTRL    @0x0;

};

`endif
