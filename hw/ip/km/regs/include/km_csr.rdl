// Key Manager Control and Status Registers (KMCSR)
// SystemRDL 2.0 Register Definition
//
// Copyright 2026 Tenstorrent Inc.
//
// Base Address: 0x0000_E000
// Size: 4KB (0x1000)

addrmap km_csr {
    name = "Key Manager Control and Status Registers";
    desc = "Control and status registers for the Key Manager MVP subsystem";

    default regwidth = 32;
    default sw = rw;
    default hw = r;

    //=========================================================================
    // Warm reset signal declaration
    //=========================================================================
    // WARM_RST_N carries both cpuif_reset (resets the AXI CPUIF state machine
    // so no in-flight transaction lingers past warm reset) and field_reset (so
    // individual fields can opt into warm reset via resetsignal = WARM_RST_N).
    // The default arst_n port is connected to cold reset in the wrapper.
    // warm_rst_ni and soft_rst_n are synchronous to clk_i at the regblock
    // boundary, so async = false is correct.
    signal warm_rst_n {
        activelow;
        async = false;
        cpuif_reset = true;
        // field_reset is intentionally NOT set here. Every warm-resettable
        // field carries an explicit `resetsignal = WARM_RST_N` so that fields
        // without one (notably BOOT_STATUS.COLD_BOOT_DONE) continue to use the
        // default arst_n (cold reset only).
    };
    warm_rst_n WARM_RST_N;

    //=========================================================================
    // VERSION Register (0x000)
    //=========================================================================
    // Canonical layout per FR-0000-076: patch[7:0], minor[15:8], major[23:16], reserved[31:24].
    // Read-only; writes must produce SLVERR (use PeakRDL --err-if-bad-rw).
    // Current version: 1.0.0 (major=1, minor=0, patch=0).
    reg version_reg {
        name = "VERSION";
        desc = "Hardware version register (semantic versioning: major.minor.patch)";

        field {
            name = "PATCH";
            desc = "Patch version number";
            sw = r;
            hw = na;
            reset = 8'h00;
        } patch[7:0];

        field {
            name = "MINOR";
            desc = "Minor version number";
            sw = r;
            hw = na;
            reset = 8'h00;
        } minor[15:8];

        field {
            name = "MAJOR";
            desc = "Major version number";
            sw = r;
            hw = na;
            reset = 8'h01;
        } major[23:16];

        field {
            name = "RSVD";
            desc = "Reserved; must read as zero";
            sw = r;
            hw = na;
            reset = 8'h00;
        } rsvd[31:24];
    };

    version_reg VERSION @ 0x000;

    //=========================================================================
    // CTRL Register (0x004)
    //=========================================================================
    reg ctrl_reg {
        name = "CTRL";
        desc = "Control register (reserved for future use)";

        field {
            name = "RSVD";
            desc = "Reserved";
            sw = r;
            hw = na;
            reset = 32'h0;
        } rsvd[31:0];
    };

    ctrl_reg CTRL @ 0x004;

    //=========================================================================
    // SOFT_RST_CODE Register (0x008)
    //=========================================================================
    reg soft_rst_code_reg {
        name = "SOFT_RST_CODE";
        desc = "Software reset code register. Write 0x53525354 ('SRST') to trigger soft reset. Any other value has no effect.";

        field {
            name = "CODE";
            desc = "32-bit reset code. Write 0x53525354 to trigger soft reset.";
            sw = rw;
            hw = r;
            resetsignal = WARM_RST_N;  // Clears after soft-reset-induced warm cycle
            reset = 32'h0;
        } code[31:0];
    };

    soft_rst_code_reg SOFT_RST_CODE @ 0x008;

    //=========================================================================
    // IRQ_STATUS Register (0x00C)
    //=========================================================================
    reg irq_status_reg {
        name = "IRQ_STATUS";
        desc = "Interrupt status register. Sticky bits cleared by writing 1.";

        field {
            name = "ROM_PARITY_ERR";
            desc = "ROM parity error detected. Sticky, write 1 to clear.";
            sw = rw;
            hw = rw;           // HW can read/write (read for IRQ aggregation, write for stickybit)
            hwset = true;      // Hardware can set this bit
            stickybit = true;  // Bit stays set until SW clears
            onwrite = woclr;   // Software writes 1 to clear
            resetsignal = WARM_RST_N;
            reset = 1'b0;
        } rom_parity_err[0:0];

        field {
            name = "SRAM_PARITY_ERR";
            desc = "SRAM parity error detected. Sticky, write 1 to clear.";
            sw = rw;
            hw = rw;           // HW can read/write (read for IRQ aggregation, write for stickybit)
            hwset = true;      // Hardware can set this bit
            stickybit = true;  // Bit stays set until SW clears
            onwrite = woclr;   // Software writes 1 to clear
            resetsignal = WARM_RST_N;
            reset = 1'b0;
        } sram_parity_err[1:1];

        field {
            name = "ROM_WRITE_ERR";
            desc = "ROM write attempt detected (ROM is read-only). Sticky, write 1 to clear.";
            sw = rw;
            hw = rw;           // HW can read/write (read for IRQ aggregation, write for stickybit)
            hwset = true;      // Hardware can set this bit
            stickybit = true;  // Bit stays set until SW clears
            onwrite = woclr;   // Software writes 1 to clear
            resetsignal = WARM_RST_N;
            reset = 1'b0;
        } rom_write_err[2:2];

        field {
            name = "SRAM_WRITE_LOCK_ERR";
            desc = "SRAM write attempt to a write-locked region detected. Sticky, write 1 to clear.";
            sw = rw;
            hw = rw;           // HW can read/write (read for IRQ aggregation, write for stickybit)
            hwset = true;      // Hardware can set this bit
            stickybit = true;  // Bit stays set until SW clears
            onwrite = woclr;   // Software writes 1 to clear
            resetsignal = WARM_RST_N;
            reset = 1'b0;
        } sram_write_lock_err[3:3];

        field {
            name = "AXI_SLVERR";
            desc = "AXI SLVERR (slave error) response detected on CPU bus transaction. Sticky, write 1 to clear.";
            sw = rw;
            hw = rw;           // HW can read/write (read for IRQ aggregation, write for stickybit)
            hwset = true;      // Hardware can set this bit
            stickybit = true;  // Bit stays set until SW clears
            onwrite = woclr;   // Software writes 1 to clear
            resetsignal = WARM_RST_N;
            reset = 1'b0;
        } axi_slverr[4:4];

        field {
            name = "AXI_DECERR";
            desc = "AXI DECERR (decode error) response detected on CPU bus transaction. Sticky, write 1 to clear.";
            sw = rw;
            hw = rw;           // HW can read/write (read for IRQ aggregation, write for stickybit)
            hwset = true;      // Hardware can set this bit
            stickybit = true;  // Bit stays set until SW clears
            onwrite = woclr;   // Software writes 1 to clear
            resetsignal = WARM_RST_N;
            reset = 1'b0;
        } axi_decerr[5:5];

        field {
            name = "DRBG_ERR";
            desc = "DRBG Sampler error (timeout or AXI-Stream error). Sticky, write 1 to clear.";
            sw = rw;
            hw = rw;           // HW can read/write (read for IRQ aggregation, write for stickybit)
            hwset = true;      // Hardware can set this bit
            stickybit = true;  // Bit stays set until SW clears
            onwrite = woclr;   // Software writes 1 to clear
            resetsignal = WARM_RST_N;
            reset = 1'b0;
        } drbg_err[6:6];

        field {
            name = "WIPE_STATE";
            desc = "Wipe state event (rising edge of wipe_state input). Sticky, write 1 to clear.";
            sw = rw;
            hw = rw;
            hwset = true;
            stickybit = true;
            onwrite = woclr;
            resetsignal = WARM_RST_N;
            reset = 1'b0;
        } wipe_state[7:7];

        field {
            name = "RSVD";
            desc = "Reserved";
            sw = r;
            hw = na;
            reset = 24'h0;
        } rsvd[31:8];
    };

    irq_status_reg IRQ_STATUS @ 0x00C;

    //=========================================================================
    // IRQ_ENABLE Register (0x010)
    //=========================================================================
    reg irq_enable_reg {
        name = "IRQ_ENABLE";
        desc = "Interrupt enable/mask register";

        field {
            name = "ROM_PARITY_EN";
            desc = "Enable ROM parity error interrupt";
            sw = rw;
            hw = r;
            resetsignal = WARM_RST_N;
            reset = 1'b0;
        } rom_parity_en[0:0];

        field {
            name = "SRAM_PARITY_EN";
            desc = "Enable SRAM parity error interrupt";
            sw = rw;
            hw = r;
            resetsignal = WARM_RST_N;
            reset = 1'b0;
        } sram_parity_en[1:1];

        field {
            name = "ROM_WRITE_EN";
            desc = "Enable ROM write error interrupt";
            sw = rw;
            hw = r;
            resetsignal = WARM_RST_N;
            reset = 1'b0;
        } rom_write_en[2:2];

        field {
            name = "SRAM_WRITE_LOCK_EN";
            desc = "Enable SRAM write-lock violation interrupt";
            sw = rw;
            hw = r;
            resetsignal = WARM_RST_N;
            reset = 1'b0;
        } sram_write_lock_en[3:3];

        field {
            name = "AXI_SLVERR_EN";
            desc = "Enable AXI SLVERR error interrupt";
            sw = rw;
            hw = r;
            resetsignal = WARM_RST_N;
            reset = 1'b0;
        } axi_slverr_en[4:4];

        field {
            name = "AXI_DECERR_EN";
            desc = "Enable AXI DECERR error interrupt";
            sw = rw;
            hw = r;
            resetsignal = WARM_RST_N;
            reset = 1'b0;
        } axi_decerr_en[5:5];

        field {
            name = "DRBG_ERR_EN";
            desc = "Enable DRBG Sampler error interrupt";
            sw = rw;
            hw = r;
            resetsignal = WARM_RST_N;
            reset = 1'b0;
        } drbg_err_en[6:6];

        field {
            name = "WIPE_STATE_EN";
            desc = "Enable wipe state interrupt";
            sw = rw;
            hw = r;
            resetsignal = WARM_RST_N;
            reset = 1'b0;
        } wipe_state_en[7:7];

        field {
            name = "RSVD";
            desc = "Reserved";
            sw = r;
            hw = na;
            reset = 24'h0;
        } rsvd[31:8];
    };

    irq_enable_reg IRQ_ENABLE @ 0x010;

    //=========================================================================
    // IRQ_SET Register (0x020) - Software Interrupt Trigger
    //=========================================================================
    // Write 1 to any bit to set the corresponding IRQ_STATUS bit.
    // This allows software to trigger interrupts for ISR testing.
    // The register is write-only; reads return 0.
    //
    // For sticky bits (parity errors, bus errors, DRBG, wipe), writing 1 sets the status bit.
    reg irq_set_reg {
        name = "IRQ_SET";
        desc = "Interrupt set register. Write 1 to trigger corresponding interrupt (for ISR testing). Write-only, reads return 0.";

        field {
            name = "ROM_PARITY_ERR_SET";
            desc = "Write 1 to set IRQ_STATUS.ROM_PARITY_ERR (triggers ROM parity interrupt for testing)";
            sw = w;
            hw = r;
            singlepulse;  // Self-clearing pulse
            resetsignal = WARM_RST_N;
            reset = 1'b0;
        } rom_parity_err_set[0:0];

        field {
            name = "SRAM_PARITY_ERR_SET";
            desc = "Write 1 to set IRQ_STATUS.SRAM_PARITY_ERR (triggers SRAM parity interrupt for testing)";
            sw = w;
            hw = r;
            singlepulse;  // Self-clearing pulse
            resetsignal = WARM_RST_N;
            reset = 1'b0;
        } sram_parity_err_set[1:1];

        field {
            name = "ROM_WRITE_ERR_SET";
            desc = "Write 1 to set IRQ_STATUS.ROM_WRITE_ERR (triggers ROM write interrupt for testing)";
            sw = w;
            hw = r;
            singlepulse;  // Self-clearing pulse
            resetsignal = WARM_RST_N;
            reset = 1'b0;
        } rom_write_err_set[2:2];

        field {
            name = "SRAM_WRITE_LOCK_ERR_SET";
            desc = "Write 1 to set IRQ_STATUS.SRAM_WRITE_LOCK_ERR (triggers SRAM write-lock interrupt for testing)";
            sw = w;
            hw = r;
            singlepulse;  // Self-clearing pulse
            resetsignal = WARM_RST_N;
            reset = 1'b0;
        } sram_write_lock_err_set[3:3];

        field {
            name = "AXI_SLVERR_SET";
            desc = "Write 1 to set IRQ_STATUS.AXI_SLVERR (triggers AXI SLVERR interrupt for testing)";
            sw = w;
            hw = r;
            singlepulse;  // Self-clearing pulse
            resetsignal = WARM_RST_N;
            reset = 1'b0;
        } axi_slverr_set[4:4];

        field {
            name = "AXI_DECERR_SET";
            desc = "Write 1 to set IRQ_STATUS.AXI_DECERR (triggers AXI DECERR interrupt for testing)";
            sw = w;
            hw = r;
            singlepulse;  // Self-clearing pulse
            resetsignal = WARM_RST_N;
            reset = 1'b0;
        } axi_decerr_set[5:5];

        field {
            name = "DRBG_ERR_SET";
            desc = "Write 1 to set IRQ_STATUS.DRBG_ERR (triggers DRBG Sampler interrupt for testing)";
            sw = w;
            hw = r;
            singlepulse;  // Self-clearing pulse
            resetsignal = WARM_RST_N;
            reset = 1'b0;
        } drbg_err_set[6:6];

        field {
            name = "WIPE_STATE_SET";
            desc = "Write 1 to set IRQ_STATUS.WIPE_STATE (triggers wipe state interrupt for testing)";
            sw = w;
            hw = r;
            singlepulse;
            resetsignal = WARM_RST_N;
            reset = 1'b0;
        } wipe_state_set[7:7];

        field {
            name = "RSVD";
            desc = "Reserved (write-only; reads trigger SLVERR via err_if_bad_rw)";
            sw = w;
            hw = na;
            reset = 24'h0;
        } rsvd[31:8];
    };

    irq_set_reg IRQ_SET @ 0x020;

    //=========================================================================
    // SCRAMBLER_KEY Register (0x014) - No reset for security (FR-0000-149)
    //=========================================================================
    reg scrambler_key_reg {
        name = "SCRAMBLER_KEY";
        desc = "32-bit scrambler key for SRAM address/data scrambling. When locked: writes ignored, reads return 0. No reset; powers up random.";

        field {
            name = "KEY";
            desc = "Scrambler key value. Not readable when SCRAMBLER_CTRL.LOCK=1 (returns 0). No reset for security; power-up value undefined.";
            sw = rw;
            hw = rw;
            // No reset: datapath must power up with random value (FR-0000-149)
            // Note: RTL must implement read-as-zero when locked via hwif_in override
        } key[31:0];
    };

    scrambler_key_reg SCRAMBLER_KEY @ 0x014;

    //=========================================================================
    // SCRAMBLER_CTRL Register (0x018)
    //=========================================================================
    reg scrambler_ctrl_reg {
        name = "SCRAMBLER_CTRL";
        desc = "Scrambler control register";

        field {
            name = "ENABLE";
            desc = "Enable SRAM scrambling. When 0, data passes through unmodified. Locked when LOCK=1 (security requirement).";
            sw = rw;
            hw = rw;
            reset = 1'b0;
            // Note: RTL must implement lock behavior - when LOCK=1, ENABLE cannot be modified via hwif_in override
        } enable[0:0];

        field {
            name = "LOCK";
            desc = "Lock scrambler key and enable bit. Once set, key and enable cannot be modified until reset. Write-once (0->1 only). Security requirement: prevents disabling scrambling after key provisioning.";
            sw = rw;
            hw = rw;
            reset = 1'b0;
            // Note: RTL must implement write-once behavior and lock ENABLE when LOCK=1 via hwif_in override
        } lock[1:1];

        field {
            name = "RSVD";
            desc = "Reserved";
            sw = r;
            hw = na;
            reset = 30'h0;
        } rsvd[31:2];
    };

    scrambler_ctrl_reg SCRAMBLER_CTRL @ 0x018;

    //=========================================================================
    // SRAM_LOCK Register (0x01C) - Write-1-only, one bit per 512-byte region
    //=========================================================================
    // Native SystemRDL woset: writing 1 sets the bit, writing 0 has no effect.
    reg sram_lock_reg {
        name = "SRAM_LOCK";
        desc = "SRAM write-lock bits. Bit[i]=1 locks region i (512 bytes each, 32 regions). Write-1-only: writing 1 sets the bit, writing 0 has no effect. Cleared only by full reset.";

        field {
            name = "LOCK_BITS";
            desc = "One bit per 512-byte SRAM region. Region 0 = 0x4000-0x41FF, region 31 = 0x7E00-0x7FFF. Write 1 to lock; 0 has no effect.";
            sw = rw;
            onwrite = woset;
            hw = r;   // Hardware only reads; storage is updated by SW woset
            reset = 32'h0;
        } lock_bits[31:0];
    };

    sram_lock_reg SRAM_LOCK @ 0x01C;

    //=========================================================================
    // SRAM_WRITE_LOCK_VIOLATION Register (0x024) - Sticky, write-1-to-clear
    //=========================================================================
    // Bit[i]=1 indicates region i had an attempted write while locked.
    // Sticky: each bit stays set until software writes 1 to clear (W1C).
    // Hardware sets bits via hwset input (32-bit vector from SRAM interface).
    reg sram_write_lock_violation_reg {
        name = "SRAM_WRITE_LOCK_VIOLATION";
        desc = "Which SRAM region(s) had write attempts while locked. Bit[i]=region i. Sticky, write 1 to clear each bit.";

        field {
            name = "VIOLATION_BITS";
            desc = "Bit[i]=1 if region i had attempted write while locked. Sticky, write 1 to clear each bit.";
            sw = rw;
            hw = rw;
            hwset = true;   // 32-bit: HW sets bits from SRAM interface violation one-hot
            stickybit = true;
            onwrite = woclr;
            resetsignal = WARM_RST_N;
            reset = 32'h0;
        } violation_bits[31:0];
    };

    sram_write_lock_violation_reg SRAM_WRITE_LOCK_VIOLATION @ 0x024;

    //=========================================================================
    // RECOVERABLE_ERR Register (0x028) - Recoverable error status
    //=========================================================================
    // Set by KM firmware (ISR) when it recovers from a recoverable fault
    // (e.g. corrupted/malformed command, or exception handled without trapping).
    // Cleared when SEP sends a firmware command to clear (KM firmware writes 0).
    // This register drives the recoverable error event output from the KM.
    reg recoverable_err_reg {
        name = "RECOVERABLE_ERR";
        desc = "Recoverable error status. Firmware writes 1 to set (after recovering in ISR), writes 0 to clear (e.g. when SEP requests clear). Drives recoverable error event output.";

        field {
            name = "RECOVERABLE_ERR";
            desc = "1 = recoverable fault occurred and was handled by ISR; 0 = clear. Write 1 to set, write 0 to clear.";
            sw = rw;
            hw = r;
            resetsignal = WARM_RST_N;
            reset = 1'b0;
        } recoverable_err[0:0];

        field {
            name = "RSVD";
            desc = "Reserved";
            sw = r;
            hw = na;
            reset = 31'h0;
        } rsvd[31:1];
    };

    recoverable_err_reg RECOVERABLE_ERR @ 0x028;

    //=========================================================================
    // BOOT_STATUS Register (0x02C) - Cold-boot done flag (firmware-set, W1S)
    //=========================================================================
    // Set by ROM firmware at the end of cold-boot initialization.
    // Firmware reads this to distinguish cold boot (0) from warm reboot (1).
    // COLD_BOOT_DONE uses the default arst_n (cold reset) and NO warm reset
    // override — it survives warm resets but clears on cold reset.
    reg boot_status_reg {
        name = "BOOT_STATUS";
        desc = "Boot status. Firmware writes 1 to COLD_BOOT_DONE after cold-boot init completes; bit remains set until next cold reset.";

        field {
            name = "COLD_BOOT_DONE";
            desc = "Write-1-only: set by ROM firmware at end of cold boot. Reads 0 after cold reset; reads 1 after firmware sets it. Sticky until next cold reset (preserved across warm resets).";
            sw = rw;
            hw = r;
            onwrite = woset;
            // Deliberately omits resetsignal = WARM_RST_N: uses default arst_n (cold reset only)
            reset = 1'b0;
        } cold_boot_done[0:0];

        field {
            name = "RSVD";
            desc = "Reserved";
            sw = r;
            hw = na;
            reset = 31'h0;
        } rsvd[31:1];
    };

    boot_status_reg BOOT_STATUS @ 0x02C;

    //=========================================================================
    // OTP Data Registers (0x030-0x0B4) - FR-0000-134–FR-0000-140
    //=========================================================================
    // Read-through from otp_data_i port.
    // Software read-only; values reflect current OTP port signals.

    reg otp_life_cycle_reg {
        name = "OTP_LIFE_CYCLE";
        desc = "Life cycle state. 8-bit (4-bit value differentially encoded). Read-through from OTP port; no reset.";
        field {
            name = "VALUE";
            desc = "8-bit life cycle state from OTP. No reset; power-up value undefined.";
            sw = r;
            hw = w;
        } value[7:0];
        field {
            name = "RSVD";
            desc = "Reserved";
            sw = r;
            hw = na;
            reset = 24'h0;
        } rsvd[31:8];
    };
    otp_life_cycle_reg OTP_LIFE_CYCLE @ 0x030;

    reg otp_demotion_state_reg {
        name = "OTP_DEMOTION_STATE";
        desc = "Demotion state. 2-bit, differentially encoded. Read-through from OTP port; no reset.";
        field {
            name = "VALUE";
            desc = "2-bit demotion 1 state from OTP. No reset; power-up value undefined.";
            sw = r;
            hw = w;
        } demote_1_value[1:0];
        field {
            name = "VALUE";
            desc = "2-bit demotion 2 state from OTP. No reset; power-up value undefined.";
            sw = r;
            hw = w;
        } demote_2_value[3:2];
        field {
            name = "RSVD";
            desc = "Reserved";
            sw = r;
            hw = na;
            reset = 30'h0;
        } rsvd[31:4];
    };
    otp_demotion_state_reg OTP_DEMOTION_STATE @ 0x034;

    // Chiplet UID: 32 × 8-bit bytes in 32 consecutive 32-bit registers (one byte per reg)
    reg otp_chiplet_uid_byte_reg {
        name = "OTP_CHIPLET_UID_BYTE";
        desc = "One byte of Device Unique Identifier (256 bits total across 32 regs). Read-through from OTP port; no reset.";
        field {
            name = "VALUE";
            desc = "8-bit UID byte from OTP. No reset; power-up value undefined.";
            sw = r;
            hw = w;
        } value[7:0];
        field {
            name = "RSVD";
            desc = "Reserved";
            sw = r;
            hw = na;
            reset = 24'h0;
        } rsvd[31:8];
    };
    otp_chiplet_uid_byte_reg OTP_CHIPLET_UID_0  @ 0x038;
    otp_chiplet_uid_byte_reg OTP_CHIPLET_UID_1  @ 0x03C;
    otp_chiplet_uid_byte_reg OTP_CHIPLET_UID_2  @ 0x040;
    otp_chiplet_uid_byte_reg OTP_CHIPLET_UID_3  @ 0x044;
    otp_chiplet_uid_byte_reg OTP_CHIPLET_UID_4  @ 0x048;
    otp_chiplet_uid_byte_reg OTP_CHIPLET_UID_5  @ 0x04C;
    otp_chiplet_uid_byte_reg OTP_CHIPLET_UID_6  @ 0x050;
    otp_chiplet_uid_byte_reg OTP_CHIPLET_UID_7  @ 0x054;
    otp_chiplet_uid_byte_reg OTP_CHIPLET_UID_8  @ 0x058;
    otp_chiplet_uid_byte_reg OTP_CHIPLET_UID_9  @ 0x05C;
    otp_chiplet_uid_byte_reg OTP_CHIPLET_UID_10 @ 0x060;
    otp_chiplet_uid_byte_reg OTP_CHIPLET_UID_11 @ 0x064;
    otp_chiplet_uid_byte_reg OTP_CHIPLET_UID_12 @ 0x068;
    otp_chiplet_uid_byte_reg OTP_CHIPLET_UID_13 @ 0x06C;
    otp_chiplet_uid_byte_reg OTP_CHIPLET_UID_14 @ 0x070;
    otp_chiplet_uid_byte_reg OTP_CHIPLET_UID_15 @ 0x074;
    otp_chiplet_uid_byte_reg OTP_CHIPLET_UID_16 @ 0x078;
    otp_chiplet_uid_byte_reg OTP_CHIPLET_UID_17 @ 0x07C;
    otp_chiplet_uid_byte_reg OTP_CHIPLET_UID_18 @ 0x080;
    otp_chiplet_uid_byte_reg OTP_CHIPLET_UID_19 @ 0x084;
    otp_chiplet_uid_byte_reg OTP_CHIPLET_UID_20 @ 0x088;
    otp_chiplet_uid_byte_reg OTP_CHIPLET_UID_21 @ 0x08C;
    otp_chiplet_uid_byte_reg OTP_CHIPLET_UID_22 @ 0x090;
    otp_chiplet_uid_byte_reg OTP_CHIPLET_UID_23 @ 0x094;
    otp_chiplet_uid_byte_reg OTP_CHIPLET_UID_24 @ 0x098;
    otp_chiplet_uid_byte_reg OTP_CHIPLET_UID_25 @ 0x09C;
    otp_chiplet_uid_byte_reg OTP_CHIPLET_UID_26 @ 0x0A0;
    otp_chiplet_uid_byte_reg OTP_CHIPLET_UID_27 @ 0x0A4;
    otp_chiplet_uid_byte_reg OTP_CHIPLET_UID_28 @ 0x0A8;
    otp_chiplet_uid_byte_reg OTP_CHIPLET_UID_29 @ 0x0AC;
    otp_chiplet_uid_byte_reg OTP_CHIPLET_UID_30 @ 0x0B0;
    otp_chiplet_uid_byte_reg OTP_CHIPLET_UID_31 @ 0x0B4;

    //=========================================================================
    // IRQ entry programmability (FR: programmable PicoRV32 IRQ vector)
    //=========================================================================
    // Effective IRQ entry address for the KM CPU. swwel gated in km_csr.sv when
    // IRQ_ENTRY_LOCK.LOCK is set (post-lock writes have no effect, readback unchanged).

    reg irq_entry_addr_reg {
        name = "IRQ_ENTRY_ADDR";
        desc = "Effective IRQ entry address for subsequent interrupts. Writable while unlocked; any 32-bit value accepted.";

        field {
            name = "ADDR";
            desc = "IRQ handler entry PC. Reset matches ROM vector at 0x10. When locked, SW writes do not update storage.";
            sw = rw;
            hw = r;
            swwel = true;
            resetsignal = WARM_RST_N;
            reset = 32'h0000_0010;
        } addr[31:0];
    };

    irq_entry_addr_reg IRQ_ENTRY_ADDR @ 0x0B8;

    reg irq_entry_lock_reg {
        name = "IRQ_ENTRY_LOCK";
        desc = "Write-one-only lock for IRQ_ENTRY_ADDR. Separate readable register; cleared only on KM reset.";

        field {
            name = "LOCK";
            desc = "Write 1 to set; write 0 has no effect; sticky until reset.";
            sw = rw;
            onwrite = woset;
            hw = r;
            resetsignal = WARM_RST_N;
            reset = 1'b0;
        } lock[0:0];

        field {
            name = "RSVD";
            desc = "Reserved; reads as zero.";
            sw = r;
            hw = na;
            reset = 31'h0;
        } rsvd[31:1];
    };

    irq_entry_lock_reg IRQ_ENTRY_LOCK @ 0x0BC;

    //=========================================================================
    // Virtual UART Registers (0x100-0x10C) - Testbench Interface
    //=========================================================================
    // These registers provide a simple virtual UART for firmware-testbench
    // communication during simulation. In synthesis, these registers exist
    // but are unused (writes are ignored, reads return default values).
    //
    // Usage:
    // - Firmware writes bytes to VUART_TX to send characters to testbench
    // - Testbench writes bytes to VUART_RX for firmware to receive
    // - VUART_STATUS provides ready/valid flags for flow control
    //
    // The testbench monitors VUART_TX.DATA_VALID and captures TX_BYTE
    // when DATA_VALID is set (self-clearing on write).

    reg vuart_tx_reg {
        name = "VUART_TX";
        desc = "Virtual UART transmit register. Write a byte to send to testbench. DATA_VALID is set on write and self-clears.";

        field {
            name = "TX_BYTE";
            desc = "Byte to transmit (write to send character to testbench)";
            sw = rw;
            hw = r;
            reset = 8'h00;
            resetsignal = WARM_RST_N;
        } tx_byte[7:0];

        field {
            name = "RSVD0";
            desc = "Reserved";
            sw = r;
            hw = na;
            reset = 23'h0;
        } rsvd0[30:8];

        field {
            name = "DATA_VALID";
            desc = "Data valid strobe. Set by firmware on write, cleared by hardware after one cycle.";
            sw = rw;
            hw = rw;
            reset = 1'b0;
            resetsignal = WARM_RST_N;
        } data_valid[31:31];
    };

    vuart_tx_reg VUART_TX @ 0x100;

    reg vuart_rx_reg {
        name = "VUART_RX";
        desc = "Virtual UART receive register. Testbench writes bytes here for firmware to read.";

        field {
            name = "RX_BYTE";
            desc = "Received byte from testbench";
            sw = r;
            hw = w;
            reset = 8'h00;
            resetsignal = WARM_RST_N;
        } rx_byte[7:0];

        field {
            name = "RSVD0";
            desc = "Reserved";
            sw = r;
            hw = na;
            reset = 23'h0;
        } rsvd0[30:8];

        field {
            name = "DATA_VALID";
            desc = "RX data valid. Set by testbench, cleared by firmware read.";
            sw = r;
            hw = w;
            reset = 1'b0;
            resetsignal = WARM_RST_N;
        } data_valid[31:31];
    };

    vuart_rx_reg VUART_RX @ 0x104;

    reg vuart_status_reg {
        name = "VUART_STATUS";
        desc = "Virtual UART status register for flow control";

        field {
            name = "TX_READY";
            desc = "TX ready to accept data (always 1 in simulation)";
            sw = r;
            hw = w;
            reset = 1'b1;
            resetsignal = WARM_RST_N;
        } tx_ready[0:0];

        field {
            name = "RX_VALID";
            desc = "RX has valid data available";
            sw = r;
            hw = w;
            reset = 1'b0;
            resetsignal = WARM_RST_N;
        } rx_valid[1:1];

        field {
            name = "PRINT_ENABLE";
            desc = "Enable VUART printing. Set by testbench to enable printf output. Disabled by default to save simulation time.";
            sw = r;
            hw = w;
            reset = 1'b0;
            resetsignal = WARM_RST_N;
        } print_enable[2:2];

        field {
            name = "RSVD";
            desc = "Reserved";
            sw = r;
            hw = na;
            reset = 29'h0;
        } rsvd[31:3];
    };

    vuart_status_reg VUART_STATUS @ 0x108;

    //=========================================================================
    // Test Protocol Registers (0x110-0x12C) - Testbench Interface
    //=========================================================================
    // These registers provide a standardized interface for firmware tests to
    // communicate results and commands with the testbench during simulation.
    // In synthesis, these registers exist but are unused.
    //
    // Protocol:
    // - Firmware writes test results to TB_RESULT, TB_SIGNATURE, TB_ERRCODE, TB_SUBTEST
    // - Firmware sends commands via TB_CMD (testbench monitors and responds)
    // - Testbench writes status/results to TB_CMD_STATUS, TB_CMD_RESULT
    //
    // This replaces the previous SRAM-based protocol which had parity issues.

    reg tb_result_reg {
        name = "TB_RESULT";
        desc = "Test result register. Firmware writes 0=fail, 1=pass.";

        field {
            name = "RESULT";
            desc = "Test result: 0=fail, 1=pass";
            sw = rw;
            hw = r;
            reset = 32'h0;
            resetsignal = WARM_RST_N;
        } result[31:0];
    };

    tb_result_reg TB_RESULT @ 0x110;

    reg tb_signature_reg {
        name = "TB_SIGNATURE";
        desc = "Test completion signature. Firmware writes 0x600D600D (pass) or 0xBADBADBA (fail).";

        field {
            name = "SIGNATURE";
            desc = "Completion signature value";
            sw = rw;
            hw = r;
            reset = 32'h0;
            resetsignal = WARM_RST_N;
        } signature[31:0];
    };

    tb_signature_reg TB_SIGNATURE @ 0x114;

    reg tb_errcode_reg {
        name = "TB_ERRCODE";
        desc = "Test error code register. Firmware writes optional error code for debugging.";

        field {
            name = "ERRCODE";
            desc = "Error code value";
            sw = rw;
            hw = r;
            reset = 32'h0;
            resetsignal = WARM_RST_N;
        } errcode[31:0];
    };

    tb_errcode_reg TB_ERRCODE @ 0x118;

    reg tb_subtest_reg {
        name = "TB_SUBTEST";
        desc = "Current subtest number register. Firmware increments for each subtest.";

        field {
            name = "SUBTEST";
            desc = "Current subtest number";
            sw = rw;
            hw = r;
            reset = 32'h0;
            resetsignal = WARM_RST_N;
        } subtest[31:0];
    };

    tb_subtest_reg TB_SUBTEST @ 0x11C;

    reg tb_cmd_reg {
        name = "TB_CMD";
        desc = "Testbench command register. Firmware writes command, testbench reads and clears.";

        field {
            name = "CMD";
            desc = "Command code (0=NOP, 1=ROM_PARITY_EN, 2=ROM_PARITY_DIS, 3=SRAM_PARITY_EN, 4=SRAM_PARITY_DIS)";
            sw = rw;
            hw = rw;
            reset = 32'h0;
            resetsignal = WARM_RST_N;
        } cmd[31:0];
    };

    tb_cmd_reg TB_CMD @ 0x120;

    reg tb_cmd_arg_reg {
        name = "TB_CMD_ARG";
        desc = "Testbench command argument register. Firmware writes optional argument.";

        field {
            name = "ARG";
            desc = "Command argument value";
            sw = rw;
            hw = r;
            reset = 32'h0;
            resetsignal = WARM_RST_N;
        } arg[31:0];
    };

    tb_cmd_arg_reg TB_CMD_ARG @ 0x124;

    reg tb_cmd_status_reg {
        name = "TB_CMD_STATUS";
        desc = "Testbench command status register. Testbench writes status, firmware reads.";

        field {
            name = "STATUS";
            desc = "Command status: 0=IDLE, 1=ACK, 0xFFFFFFFF=ERR";
            sw = rw;
            hw = w;
            reset = 32'h0;
            resetsignal = WARM_RST_N;
        } status[31:0];
    };

    tb_cmd_status_reg TB_CMD_STATUS @ 0x128;

    reg tb_cmd_result_reg {
        name = "TB_CMD_RESULT";
        desc = "Testbench command result register. Testbench writes result value.";

        field {
            name = "RESULT";
            desc = "Command result value";
            sw = r;
            hw = w;
            reset = 32'h0;
            resetsignal = WARM_RST_N;
        } result[31:0];
    };

    tb_cmd_result_reg TB_CMD_RESULT @ 0x12C;

    //=========================================================================
    // DEBUG Register (0x1FC) - Read-only debug/verification register
    //=========================================================================
    // This register contains a known constant value (0xCAFE_BEEF) that can be
    // read to verify KMCSR access is working correctly. Used for debugging.

    reg debug_reg {
        name = "DEBUG";
        desc = "Debug register with known constant value for verification";

        field {
            name = "MAGIC";
            desc = "Magic constant: 0xCAFEBEEF";
            sw = r;
            hw = na;
            reset = 32'hCAFEBEEF;
        } magic[31:0];
    };

    debug_reg DEBUG @ 0x1FC;

};
