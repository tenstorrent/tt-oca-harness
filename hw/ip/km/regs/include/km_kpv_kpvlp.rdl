// Key and Policy Vault Load Port (KPVLP) - SEP Register Definition
// SystemRDL 2.0
//
// Copyright 2026 Tenstorrent Inc.
//
// Base Address: Integration-defined (not in KM memory map)
// KPVLP has its own register set (separate from km_kpv.rdl). Window into KPV:
// - Key entry data: write-only (no read access)
// - Slot control (Extend, Dest_valid, Last_dword): write-only per slot
// - STATUS: read-only (bit N = unlock_sep for slot N)
// FR-0000-098, FR-0000-099, FR-0000-107, FR-0000-108, FR-0000-109, FR-0000-110

addrmap km_kpv_kpvlp {
    name = "Key and Policy Vault Load Port (KPVLP)";
    desc = "Write-only key/control window; read-only STATUS. Access conditioned by unlock_sep and lock_write.";

    default regwidth = 32;
    default sw = rw;
    default hw = r;

    //=========================================================================
    // Key Word Register (write-only from KPVLP; no read access)
    // No reset for security (FR-0000-149); power-up value undefined.
    // Prefix KPVLP_ on types to avoid C header clash with km_kpv (key_manager_regs.h).
    //=========================================================================
    reg kpvlp_key_word_reg {
        name = "KEY_WORD";
        desc = "One 32-bit word of key data. Write-only; reads not supported. No reset; powers up random.";

        field {
            name = "DATA";
            desc = "32-bit key data word (write-only). No reset for security; power-up value undefined.
                    Actual storage is in km_kpv_regfile; CSR field is a protocol placeholder.";
            sw = w;
            hw = na;       // No HW interface: key data stored in external register file
            // No reset: datapath must power up with random value (FR-0000-149)
        } data[31:0];
    };

    regfile kpvlp_key_entry_rf {
        name = "KEY_ENTRY";
        desc = "One key entry (16 words = 512 bits). Write-only.";

        kpvlp_key_word_reg WORD[16] @ 0x000;
    };

    // External: no internal flops; RTL bridges to km_kpv_regfile via req/ack interface.
    external kpvlp_key_entry_rf KPVLP_KEY_ENTRY[32] @ 0x000;

    //=========================================================================
    // Slot Control (writable fields only: Extend, Dest_valid, Last_dword)
    // KPVLP writes to Lock_write, Lock_use, Unlock_sep, reserved
    // return OKAY and do not update those bits (FR-0000-110). RTL implements.
    // Prefix KPVLP_ on types/instances to avoid C header clash with km_kpv.
    //=========================================================================
    reg kpvlp_ctrl_writable_reg {
        name = "CTRL";
        desc = "Per-slot writable fields only: Extend, Dest_valid, Last_dword. Other bits ignored on write.";

        field {
            name = "EXTEND";
            desc = "Zero-indexed number of additional slots for wide keys.";
            sw = w;
            hw = rw;
            reset = 3'h0;
        } extend[6:4];

        field {
            name = "RSVD_8_7";
            desc = "Reserved (writes ignored by RTL)";
            sw = w;
            hw = na;
            reset = 2'h0;
        } rsvd_8_7[8:7];

        field {
            name = "DEST_VALID";
            desc = "Which crypto block may consume this key.";
            sw = w;
            hw = rw;
            reset = 8'h0;
        } dest_valid[16:9];

        field {
            name = "LAST_DWORD";
            desc = "Last valid key word index [1,15].";
            sw = w;
            hw = rw;
            reset = 4'h0;
        } last_dword[20:17];

        field {
            name = "RSVD_31_21";
            desc = "Reserved (writes ignored by RTL)";
            sw = w;
            hw = na;
            reset = 11'h0;
        } rsvd_31_21[31:21];
    };

    kpvlp_ctrl_writable_reg KPVLP_CTRL[32] @ 0x800;

    //=========================================================================
    // STATUS Register (read-only): bit N = unlock_sep for slot N
    // FR-0000-109. Prefix KPVLP_ on type/instance to avoid C header clash.
    //=========================================================================
    reg kpvlp_status_reg {
        name = "STATUS";
        desc = "Read-only: bit N = unlock_sep for slot N (all 32 slots).";

        field {
            name = "UNLOCK_SEP";
            desc = "Bit N = 1 if slot N has unlock_sep set (SEP may write when lock_write==0)";
            sw = r;
            hw = w;
            reset = 32'h0;
        } unlock_sep[31:0];
    };

    kpvlp_status_reg KPVLP_STATUS @ 0x880;
};
