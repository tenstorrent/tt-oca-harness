// SPDX-License-Identifier: Apache-2.0
// SPDX-FileCopyrightText: 2026 Tenstorrent USA, Inc.

`ifndef CROSS_TRIGGER_MATRIX_RDL
`define CROSS_TRIGGER_MATRIX_RDL

//------------------------------------------------------------------------------
// Copyright 2025 Tenstorrent Inc.
// Cross Trigger Matrix Configuration Registers
//
// One configuration register per CT_Src output port, declared as an array sized
// by NUM_CT_SRC. Each port occupies 8 bytes: CONFIG_0 selects among CT_Dst[31:0]
// and the second doubleword is reserved for CT_Dst[63:32].
//
// The array is wrapped in a regfile because the C header exporter rejects a
// register array whose stride exceeds the register width.
//------------------------------------------------------------------------------

addrmap cross_trigger_matrix #(
    longint unsigned NUM_CT_SRC = 26
) {
    name = "Cross Trigger Matrix Address Map";
    desc = "Configuration registers for the cross trigger matrix";

    regfile {
        name = "Cross Trigger Source Configuration";
        desc = "Cross trigger destination selection for one CT_Src output port";

        reg {
            desc = "Cross Trigger Source Configuration - Lower 32 CT_Dst ports";
            field {
                sw = rw;
                hw = r;
                desc = "Selects the CT_Dst port(s) to forward on the CT_Src output
                        at this array index. Each bit is mapped to a CT_Dst port
                        (bits [25:0] correspond to CT_Dst[25:0]). Multiple ports
                        may be selected as a trigger source. All selected source
                        ports are then OR'd together to produce the CT_Src output.
                        Set this register to all-zero to disable that output. Bits
                        [31:26] are reserved and should be written as zero.";
            } CT_DST_SELECT[25:0] = 0x0;
            field {
                sw = rw;
                hw = r;
                desc = "Reserved. Must be written as zero.";
            } RESERVED[31:26] = 0x0;
        } CONFIG_0 @0x0;
    } CT_SRC[NUM_CT_SRC] @0x0 += 0x8;
};

`endif
