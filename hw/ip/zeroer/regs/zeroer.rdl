`ifndef ZEROER_REG_RDL
`define ZEROER_REG_RDL

addrmap zeroer_ctrl {
    desc = "AXI zeroer control register";

    ////////////////////////////////////////////////////////////////////////////
    // Register Definitions
    ////////////////////////////////////////////////////////////////////////////

    reg DEST_ADDR {
        regwidth = 64;
        accesswidth = 64;
        field {
            sw = rw;
            hw = r;
            desc = "Byte address to write zeros to";
        } DEST_ADDR[63:0] = 0x0;
    };

    reg SIZE {
        regwidth = 64;
        accesswidth = 64;
        field {
            sw = rw;
            hw = r;
            desc = "Size in bytes of zeros to write";
        } SIZE[63:0] = 0x0;
    };

    reg CTRL_STATUS {
        regwidth = 64;
        accesswidth = 64;

        desc = "Writing this register will trigger start of zeroer";

        field {
            sw = rw;
            hw = r;
            wr_swacc = true;
            desc = "If enabled, an interrupt will be outputted once zeroer completes.";
        } INT_EN[0:0] = 0x0;

        field {
            sw = r;
            hw = w;
            rd_swacc = true;
            desc = "Returns status of whether zeroer has completed.";
        } STATUS[32:32] = 0x0;
    };

    ////////////////////////////////////////////////////////////////////////////
    // Address Map
    ////////////////////////////////////////////////////////////////////////////

    DEST_ADDR       DEST_ADDR       @0x0;
    SIZE            SIZE            @0x8;
    CTRL_STATUS     CTRL_STATUS     @0x10;
};

`endif