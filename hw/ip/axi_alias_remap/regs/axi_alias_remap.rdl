`ifndef ALIAS_REMAP_REG_RDL
`define ALIAS_REMAP_REG_RDL

addrmap alias_remap {
    desc = "TLB Registers for address remapping and attribute tagging";

    ////////////////////////////////////////////////////////////////////////////
    // Register Definitions
    ////////////////////////////////////////////////////////////////////////////

    regfile remap_region {
        reg REGION_START {
            regwidth = 64;
            accesswidth = 64;
            field {
                sw = rw;
                hw = r;
                desc = "Start of remap region";
            } start_addr [55:12] = 0x0;
        };

        reg REGION_END {
            regwidth = 64;
            accesswidth = 64;
            field {
                sw = rw;
                hw = r;
                desc = "End of remap region (non-inclusive).";
            } end_addr [55:12] = 0x0;
        };

        reg REGION_ATTRS {
            regwidth = 64;
            accesswidth = 64;
            field {
                sw = rw;
                hw = r;
                desc = "The value of this field is added to bits [55:12] of the input address when it falls within the remap region. The lower 12 bits of the address are preserved unchanged.";
            } offset [55:12] = 0x0;

            field {
                sw = rw;
                hw = r;
                desc = "If set, top two bits of a*cache will be tied high";
            } cacheable[62:62] = 0x0;

            field {
                sw = rw;
                hw = r;
                desc = "If set, this remap will be active";
            } valid[63:63] = 0x0;
        };

        // Register instantiations with addresses
        REGION_START region_start @0x00;
        REGION_END region_end @0x08;
        REGION_ATTRS region_attrs @0x10;
    };

    ////////////////////////////////////////////////////////////////////////////
    // Address Map
    ////////////////////////////////////////////////////////////////////////////

    remap_region REGION @0x00;
};

`endif
