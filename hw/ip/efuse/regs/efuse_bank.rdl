// SPDX-License-Identifier: Apache-2.0
// SPDX-FileCopyrightText: 2026 Tenstorrent USA, Inc.

`ifndef EFUSE_BANK_RDL_DEFINED
`define EFUSE_BANK_RDL_DEFINED
addrmap efuse_bank {

    reg EFUSE_BANK_REG {
        desc = "eFuse bank storage word. Models a single 32-bit OTP word in the reference bank model, using write-one-to-set semantics to emulate set-once OTP behavior.";
        regwidth = 32;
        accesswidth = 32;
        field {
            sw = rw;
            onwrite = woset;
            hw = r;
            desc = "Read Data from eFuse";
        } dout[31:0] = 0x0;
    };

    EFUSE_BANK_REG        EFUSE_BANK_REG[1024]     @0x0;
};

`endif
