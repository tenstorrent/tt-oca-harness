// SPDX-License-Identifier: Apache-2.0
// SPDX-FileCopyrightText: 2026 Tenstorrent USA, Inc.

`ifndef EFUSE_INTERFACE_CTRL_RDL_DEFINED
`define EFUSE_INTERFACE_CTRL_RDL_DEFINED
addrmap efuse_interface_ctrl {
    name = "eFuse Interface Control Address Map";
    desc = "Program and read command, address, data, status, and timeout registers for the eFuse interface.";

    reg EFUSE_INTERFACE_CTRL_STATUS {
        desc = "eFuse interface status and error-clear register. Reports the sense-done flag and request/address error conditions, and provides write-1 strobes to clear those errors.";
        regwidth = 32;
        accesswidth = 32;

        field {
            sw = r;
            hw = w;
            desc = "Indicates if the eFuse state machine has completed";
        } efuse_sense_done [0:0];

        field {
            sw=r;
            hw=w;
            desc = "Indicates that the eFuse was blocked because of either read or a program lock.  The error must be cleared by writing 1 to efuse_req_error_clear to this register";
        } efuse_req_error [4:4] = 0x0;

        field {
            sw=r;
            hw=w;
            desc = "Indicates that an invalid eFuse program address was used (address exceeds the implemented eFuse size). The error must be cleared by writing 1 to efuse_program_addr_error_clear.";
        } efuse_program_addr_error [5:5] = 0x0;

        field {
            sw=r;
            hw=w;
            desc = "Indicates that an invalid eFuse read address was used (address exceeds the implemented eFuse size). The error must be cleared by writing 1 to efuse_read_addr_error_clear.";
        } efuse_read_addr_error [6:6] = 0x0;

        field {
            sw=w;
            hw=r;
            singlepulse = true;
            desc = "Clears the blocked request error bit in efuse_ctrl_status";
        } efuse_req_error_clear [8:8] = 0x0;

        field {
            sw=w;
            hw=r;
            singlepulse = true;
            desc = "Clears the program out of bounds error bit (efuse_program_addr_error) in efuse_ctrl_status";
        } efuse_program_addr_error_clear [9:9] = 0x0;

        field {
            sw=w;
            hw=r;
            singlepulse = true;
            desc = "Clears the read out of bounds error bit (efuse_read_addr_error) in efuse_ctrl_status";
        } efuse_read_addr_error_clear [10:10] = 0x0;
    };

    reg EFUSE_PROGRAM_CTRL {
        desc = "eFuse program control and status. Configures the program data, triggers a program of the bit at EFUSE_PROGRAM_ADDR, and reports program progress and completion status.";
        regwidth = 32;
        accesswidth = 32;

        field {
            sw=rw;
            hw=r;
            desc="Data to program to eFuse.  If this bit is 0, a program request is refused: it issues no command and completes at once with program_done 1 and program_status 1";
        } efuse_data [16:16] = 0x0;

        field {
            sw = rw;
            hw = r;
            singlepulse = true;
            desc = "When set, triggers a program to the eFuse.  A request made while program_enable is clear, efuse_data is 0, the address is out of bounds, or the bit is locked or blocked is refused: it issues no command and completes at once with program_done 1 and program_status 1";
        } efuse_program_go [17:17] = 0x0;

        // bit 18: reserved

        field {
            sw=r;
            hw=w;
            desc="When set, the program is in progress";
        } program_busy [24:24] = 0x0;

        field {
            sw=r;
            hw=w;
            desc="When set, the program has completed, the status of which is in program_status.  Cleared when the next efuse_program_go is accepted; a refused request leaves it set and updates program_status";
        } program_done[25:25] = 0x0;

        field {
            sw=r;
            hw=w;
            desc="0: No Error.  1: Error. Set when efuse_program_go is refused, or the program request fails or times out.";
        } program_status [26:26] = 0x0;

        field {
            sw=rw;
            hw=r;
            desc="When set, enables the program request";
        } program_enable [27:27] = 0x0;
    };

     reg EFUSE_READ_CTRL {
        desc = "eFuse read control and status. Triggers a read of the word at EFUSE_READ_ADDR and reports read progress and completion status.";
        regwidth = 32;
        accesswidth = 32;

        field {
            sw = rw;
            hw = r;
            singlepulse = true;
            desc = "When set, triggers a read to efuse.  A request made while read_enable is clear, the address is out of bounds, or the word is locked or blocked is refused: it issues no command and completes at once with read_done 1 and read_status 1";
        } efuse_read_go [16:16] = 0x0;

        field {
            sw=r;
            hw=w;
            desc="When set, the read is in progress";
        } read_busy [24:24] = 0x0;

        field {
            sw=r;
            hw=w;
            desc="When set, the read has completed, the status of which is in read_status.  Cleared when the next efuse_read_go is accepted; a refused request leaves it set and updates read_status";
        } read_done[25:25] = 0x0;

        field {
            sw=r;
            hw=w;
            desc="0: No Error.  1: Error. Set when read_go is asserted while read is not enabled, the address is out of bounds, or the read request times out.";
        } read_status [26:26] = 0x0;

        field {
            sw=rw;
            hw=r;
            desc="When set, enables the read request";
        } read_enable [28:28] = 0x0;
    };

    reg EFUSE_PROGRAM_INTERFACE_READ_DATA {
        desc = "Data the adopter SHIM returned with the last successful program, for example a read-back word. Held until the next successful program and not valid after an error. Hardware debug only.";
        field {
        sw = r;
        hw = w;
        desc = "Program response data from the adopter SHIM; its meaning is adopter-defined.";
        } dout[31:0] = 0x0;
    };

     reg EFUSE_READ_INTERFACE_READ_DATA {
        desc = "Read data returned through the eFuse read interface.";
        field {
        sw = r;
        hw = w;
        desc = "Read Data from eFuse through READ interface.";
        } dout[31:0] = 0x0;
    };

    reg EFUSE_READ_REQ_TIMEOUT {
        desc = "Read interface timeout configuration. Sets the number of cycles the read interface waits for a SHIM response and enables the read timeout.";
        regwidth = 32;
        accesswidth = 32;
        field  {
            sw=rw;
            hw=r;
            desc="Number of cycles the read interface will wait for a response from the shim. At 100MHz this can count ~= 2.5 seconds.";
        } read_req_timeout_cycles [27:0] = 0x800000;

        field {
            sw = rw;
            hw=r;
            desc="Enable timeout on read interface";
        } read_req_timout_enable [28:28] = 0x0;
    };

    reg EFUSE_PROGRAM_REQ_TIMEOUT {
        desc = "Program interface timeout configuration. Sets the number of cycles the program interface waits for a SHIM response and enables the program timeout.";
        regwidth = 32;
        accesswidth = 32;
        field {
            sw=rw;
            hw=r;
            desc="Number of cycles the program interface will wait for a response from the shim. At 100MHz this can count ~= 2.5 seconds.";
        } program_req_timeout_cycles [27:0] = 0x800000;

        field {
            sw = rw;
            hw=r;
            desc="Enable timeout on program interface.";
        } program_req_timeout_enable [28:28] = 0x0;
    };

    reg EFUSE_PROGRAM_ADDR {
        desc = "Bit address for the next program. Set it before EFUSE_PROGRAM_CTRL.efuse_program_go.";
        regwidth = 32;
        accesswidth = 32;
        field {
            sw = rw;
            hw = r;
            desc = "Bit address to program. Writing this register does not check the address; a program started with an address at or beyond the implemented eFuse size is not issued and sets efuse_program_addr_error.";
        } efuse_addr [31:0] = 0x0;
    };

    reg EFUSE_READ_ADDR {
        desc = "Bit address for the next read. Set it before EFUSE_READ_CTRL.efuse_read_go.";
        regwidth = 32;
        accesswidth = 32;
        field {
            sw = rw;
            hw = r;
            desc = "Bit address of the word to read. Writing this register does not check the address; a read started with an address at or beyond the implemented eFuse size is not issued and sets efuse_read_addr_error.";
        } efuse_addr [31:0] = 0x0;
    };


    EFUSE_INTERFACE_CTRL_STATUS           EFUSE_INTERFACE_CTRL_STATUS        @0x0;

    EFUSE_PROGRAM_CTRL                    EFUSE_PROGRAM_CTRL                 @0x4;
    EFUSE_READ_CTRL                       EFUSE_READ_CTRL                    @0x8;

    EFUSE_PROGRAM_INTERFACE_READ_DATA     EFUSE_PROGRAM_INTERFACE_READ_DATA  @0xC;
    EFUSE_READ_INTERFACE_READ_DATA        EFUSE_READ_INTERFACE_READ_DATA     @0x10;

    EFUSE_READ_REQ_TIMEOUT                EFUSE_READ_REQ_TIMEOUT             @0x14;
    EFUSE_PROGRAM_REQ_TIMEOUT             EFUSE_PROGRAM_REQ_TIMEOUT          @0x18;

    EFUSE_PROGRAM_ADDR                    EFUSE_PROGRAM_ADDR                 @0x1C;
    EFUSE_READ_ADDR                       EFUSE_READ_ADDR                    @0x20;
};

`endif
