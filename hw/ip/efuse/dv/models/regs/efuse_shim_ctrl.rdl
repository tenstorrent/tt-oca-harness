// SPDX-License-Identifier: Apache-2.0
// SPDX-FileCopyrightText: 2026 Tenstorrent USA, Inc.

`ifndef EFUSE_SHIM_CTRL_RDL_DEFINED
`define EFUSE_SHIM_CTRL_RDL_DEFINED
addrmap efuse_shim_ctrl {
    name = "eFuse SHIM Control Model Address Map";
    desc = "DV model of the eFuse SHIM control interface.";

    reg EFUSE_BANK_INIT_TIME {
        desc = "eFuse bank initialization time. Number of cycles to wait for the OTP macro to initialize before sensing can begin.";
        regwidth = 32;
        accesswidth = 32;
        field {
            sw=rw;
            hw=r;
            desc="Most OTP have a initialization time before sensing can be done";
        } init_time [31:0] = 0x20;
    };

    EFUSE_BANK_INIT_TIME                     EFUSE_BANK_INIT_TIME                  @0x0;
};

`endif
