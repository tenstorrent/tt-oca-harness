// SPDX-License-Identifier: Apache-2.0
// SPDX-FileCopyrightText: 2026 Tenstorrent USA, Inc.

`ifndef SEP_ADOPTER_FUSE_LOCKS_RDL
`define SEP_ADOPTER_FUSE_LOCKS_RDL

`include "sep_adopter_fuse_map.rdl"

// Harness-owned. The adopter provides sep_adopter_fuse_map.rdl (exact filename) with its payload
// fields only; the harness places it after LOCKS and never interprets it.
//
// The payload is split into 32 equal slices of 2^k 32-bit words, k chosen so that 32 slices cover
// the payload. Lock pair n (write lock at bit 2n, read lock at bit 2n+1) governs slice n. A field
// that must be locked on its own starts and ends on a slice boundary.
//
// The adopter region carries no static policy: every slice is write-unlocked, read-unlocked and has
// no secure-test lock, so firmware may override the shadow until it sets the slice's write lock.
// The region must not hold secrets.

// One lock bit: set by a write of 1 to the shadow copy until reset, or permanently by burning it.
field adopter_lock_f {
    sw = rw;
    onwrite = woset;
    hw = r;
    desc = "When set, the governed payload slice is locked for this access type, in both the fuses and
            the shadow copy.";
};

reg sep_adopter_fuse_locks {
    name = "SEP adopter fuse locks";
    desc = "32 write/read lock pairs. Pair n governs payload slice n.";
    regwidth = 64;
    accesswidth = 64;

    adopter_lock_f slice0_write_lock[0:0] = 0x0;
    adopter_lock_f slice0_read_lock[1:1] = 0x0;
    adopter_lock_f slice1_write_lock[2:2] = 0x0;
    adopter_lock_f slice1_read_lock[3:3] = 0x0;
    adopter_lock_f slice2_write_lock[4:4] = 0x0;
    adopter_lock_f slice2_read_lock[5:5] = 0x0;
    adopter_lock_f slice3_write_lock[6:6] = 0x0;
    adopter_lock_f slice3_read_lock[7:7] = 0x0;
    adopter_lock_f slice4_write_lock[8:8] = 0x0;
    adopter_lock_f slice4_read_lock[9:9] = 0x0;
    adopter_lock_f slice5_write_lock[10:10] = 0x0;
    adopter_lock_f slice5_read_lock[11:11] = 0x0;
    adopter_lock_f slice6_write_lock[12:12] = 0x0;
    adopter_lock_f slice6_read_lock[13:13] = 0x0;
    adopter_lock_f slice7_write_lock[14:14] = 0x0;
    adopter_lock_f slice7_read_lock[15:15] = 0x0;
    adopter_lock_f slice8_write_lock[16:16] = 0x0;
    adopter_lock_f slice8_read_lock[17:17] = 0x0;
    adopter_lock_f slice9_write_lock[18:18] = 0x0;
    adopter_lock_f slice9_read_lock[19:19] = 0x0;
    adopter_lock_f slice10_write_lock[20:20] = 0x0;
    adopter_lock_f slice10_read_lock[21:21] = 0x0;
    adopter_lock_f slice11_write_lock[22:22] = 0x0;
    adopter_lock_f slice11_read_lock[23:23] = 0x0;
    adopter_lock_f slice12_write_lock[24:24] = 0x0;
    adopter_lock_f slice12_read_lock[25:25] = 0x0;
    adopter_lock_f slice13_write_lock[26:26] = 0x0;
    adopter_lock_f slice13_read_lock[27:27] = 0x0;
    adopter_lock_f slice14_write_lock[28:28] = 0x0;
    adopter_lock_f slice14_read_lock[29:29] = 0x0;
    adopter_lock_f slice15_write_lock[30:30] = 0x0;
    adopter_lock_f slice15_read_lock[31:31] = 0x0;
    adopter_lock_f slice16_write_lock[32:32] = 0x0;
    adopter_lock_f slice16_read_lock[33:33] = 0x0;
    adopter_lock_f slice17_write_lock[34:34] = 0x0;
    adopter_lock_f slice17_read_lock[35:35] = 0x0;
    adopter_lock_f slice18_write_lock[36:36] = 0x0;
    adopter_lock_f slice18_read_lock[37:37] = 0x0;
    adopter_lock_f slice19_write_lock[38:38] = 0x0;
    adopter_lock_f slice19_read_lock[39:39] = 0x0;
    adopter_lock_f slice20_write_lock[40:40] = 0x0;
    adopter_lock_f slice20_read_lock[41:41] = 0x0;
    adopter_lock_f slice21_write_lock[42:42] = 0x0;
    adopter_lock_f slice21_read_lock[43:43] = 0x0;
    adopter_lock_f slice22_write_lock[44:44] = 0x0;
    adopter_lock_f slice22_read_lock[45:45] = 0x0;
    adopter_lock_f slice23_write_lock[46:46] = 0x0;
    adopter_lock_f slice23_read_lock[47:47] = 0x0;
    adopter_lock_f slice24_write_lock[48:48] = 0x0;
    adopter_lock_f slice24_read_lock[49:49] = 0x0;
    adopter_lock_f slice25_write_lock[50:50] = 0x0;
    adopter_lock_f slice25_read_lock[51:51] = 0x0;
    adopter_lock_f slice26_write_lock[52:52] = 0x0;
    adopter_lock_f slice26_read_lock[53:53] = 0x0;
    adopter_lock_f slice27_write_lock[54:54] = 0x0;
    adopter_lock_f slice27_read_lock[55:55] = 0x0;
    adopter_lock_f slice28_write_lock[56:56] = 0x0;
    adopter_lock_f slice28_read_lock[57:57] = 0x0;
    adopter_lock_f slice29_write_lock[58:58] = 0x0;
    adopter_lock_f slice29_read_lock[59:59] = 0x0;
    adopter_lock_f slice30_write_lock[60:60] = 0x0;
    adopter_lock_f slice30_read_lock[61:61] = 0x0;
    adopter_lock_f slice31_write_lock[62:62] = 0x0;
    adopter_lock_f slice31_read_lock[63:63] = 0x0;
};

addrmap sep_adopter_fuse_region {
    name = "SEP adopter fuse region";
    desc = "Harness-owned LOCKS followed by the adopter-defined payload. Sensed after the SEP harness
            fuses, at fuse bit address 8192 onwards.";

    sep_adopter_fuse_locks LOCKS   @0x0;
    sep_adopter_fuse_map   payload @0x8;
};

`endif
