// SPDX-License-Identifier: Apache-2.0
// SPDX-FileCopyrightText: 2026 Tenstorrent USA, Inc.

// Stub I3CCSR register map for the open build.
//
// The real I3CCSR map (MIPI HCI 1.2, ~1.3k register fields across I3CBASE /
// PIOControl / I3C_EC / DAT / DCT) is defined in the bender-vendored i3c-core
// fork under vendor/chipsalliance/i3c-core/upstream/src/rdl/registers.rdl.
// This file is the fallback used when that vendor tree has not been
// materialized, so the full field detail is unavailable here.
//
// oca_i3c_wrap instantiates I3CCSR as an addrmap-in-addrmap, which PeakRDL
// treats as a single external region: the generated wrapper only exposes an
// external cpuif passthrough (req/addr/data), never the internal fields. This
// stub therefore only needs to reserve the correct address window (0x500,
// 11-bit address space) so oca_i3c_wrap regenerates an identical SV wrapper
// and a size-accurate C/address map. When i3c-core is un-stubbed (bender
// vendor init materializes the upstream RDL), this file's include is shadowed
// by the real registers.rdl on the -I path and full field detail returns.

`ifndef I3C_STUB_REGISTERS_RDL
`define I3C_STUB_REGISTERS_RDL

addrmap I3CCSR {
    desc = "I3C controller CSR (stub: external address window only; real map is
            vendored from i3c-core and stubbed out of the open build)";

    // Reserve the full 0x500 window as one external memory region so the
    // enclosing wrapper decodes addresses 0x000..0x4ff to the external cpuif.
    mem {
        name       = "I3CCSR external window";
        mementries = 320;   // 0x500 bytes / 4 bytes-per-word = 0x140 = 320 words
        memwidth   = 32;
        sw         = rw;
    } external i3ccsr_window @0x0;
};

`endif
