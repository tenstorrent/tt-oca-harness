// SPDX-License-Identifier: Apache-2.0
// SPDX-FileCopyrightText: 2026 Tenstorrent USA, Inc.

// DFD (CLA + DST + trace sink) MMR map as built by dfd_top_cla_dst_apb with
// NUM_CLA_INST=1, NUM_DST_INST=1, NUM_NTRACE_INST=0, TRACE_SINK_SUPPORT=1,
// NTRACE_SUPPORT=0 -- the parameters smc_dfd_wrap instantiates.
//
// mmrs.sv assigns one 4 KiB MMR block per present unit, in this order, and
// decodes the block from paddr[22:12]:
//
//   +0x0000  DST trace sink   DST_SINK_BLK_IDX = 0
//   +0x1000  Trace funnel     FUNNEL_BLK_IDX   = DST_SINK_EN + NTR_SINK_EN
//   +0x2000  CLA              CLA_START_IDX    = DST_SINK_EN + NTR_SINK_EN + 1
//   +0x3000  DST trace source DST_START_IDX    = CLA_START_IDX + NUM_CLA_INST
//
// NUM_MMR_BLOCKS is therefore 4 and the aperture is 16 KiB. An access inside
// a block that hits no register never asserts pready (apb2mmr.sv), so this
// map must not describe registers the build does not instantiate.
//
// Field geometry comes from vendor/tenstorrent/tt-hw-debug/upstream/rtl/mmr/
// <blk>_mmr_pkg.svh; reset values and the sw/hw write paths come from the
// matching <blk>_mmr.sv. Keep them in step when the vendor drop is bumped.
//
// The exception is HW_OWNED in the generator: a handful of live counters and
// pointers that the block rewrites after every software write. Their RTL is
// shaped like ordinary rw config, so they read as writable here and have to be
// pinned read-only by hand -- smc_register_test flags each one otherwise.

addrmap smc_cla {

    // ---------------------------------------------------------------------
    // DST trace-sink MMRs   (mmrs.sv block 0, DST_SINK_BLK_IDX)
    // ---------------------------------------------------------------------
    reg {
        regwidth = 0x20;

        field {
            sw = rw;
            hw = rw;
        } Trdstramactive[0:0] = 0x0;
        field {
            sw = rw;
            hw = rw;
        } Trdstramenable[1:1] = 0x0;
        field {
            sw = r;
            hw = w;
        } Trdstramempty[3:3] = 0x1;
        field {
            sw = rw;
            hw = rw;
        } Trdstrammode[4:4] = 0x0;
        field {
            sw = rw;
            hw = rw;
        } Trdstramstoponwrap[8:8] = 0x0;
    } Trdstramcontrol @ 0x0;
    reg {
        regwidth = 0x20;

        field {
            sw = r;
            hw = r;
        } Trdstramvermajor[3:0] = 0x1;
        field {
            sw = r;
            hw = r;
        } Trdstramverminor[7:4] = 0x0;
        field {
            sw = r;
            hw = r;
        } Trdstramcomptype[11:8] = 0x9;
        field {
            sw = r;
            hw = r;
        } Trdstramhassram[12:12] = 0x1;
        field {
            sw = r;
            hw = r;
        } Trdstramhassmem[13:13] = 0x1;
        field {
            sw = rw;
            hw = r;
        } Trdstramvendorframelength[27:24] = 0x1;
    } Trdstramimpl @ 0x4;
    reg {
        regwidth = 0x20;

        field {
            sw = r;
            hw = r;
        } Rsvd10[1:0] = 0x0;
        field {
            sw = rw;
            hw = rw;
        } Trdstramstartlow[31:2] = 0x0;
    } Trdstramstartlow @ 0x10;
    reg {
        regwidth = 0x20;

        field {
            sw = rw;
            hw = rw;
        } Trdstramstarthigh[31:0] = 0x0;
    } Trdstramstarthigh @ 0x14;
    reg {
        regwidth = 0x20;

        field {
            sw = r;
            hw = r;
        } Rsvd10[1:0] = 0x0;
        field {
            sw = rw;
            hw = rw;
        } Trdstramlimitlow[31:2] = 0x0;
    } Trdstramlimitlow @ 0x18;
    reg {
        regwidth = 0x20;

        field {
            sw = rw;
            hw = rw;
        } Trdstramlimithigh[31:0] = 0x0;
    } Trdstramlimithigh @ 0x1C;
    reg {
        regwidth = 0x20;

        field {
            sw = r;
            hw = w;
        } Trdstramwrap[0:0] = 0x0;
        field {
            sw = rw;
            hw = rw;
        } Trdstramwplow[31:2] = 0x0;
    } Trdstramwplow @ 0x20;
    reg {
        regwidth = 0x20;

        field {
            sw = r;
            hw = w;
        } Trdstramwphigh[31:0] = 0x0;
    } Trdstramwphigh @ 0x24;
    reg {
        regwidth = 0x20;

        field {
            sw = r;
            hw = r;
        } Rsvd10[1:0] = 0x0;
        field {
            sw = rw;
            hw = rw;
        } Trdstramrplow[31:2] = 0x0;
    } Trdstramrplow @ 0x28;
    reg {
        regwidth = 0x20;

        field {
            sw = rw;
            hw = rw;
        } Trdstramrphigh[31:0] = 0x0;
    } Trdstramrphigh @ 0x2C;
    reg {
        regwidth = 0x20;

        field {
            sw = r;
            hw = w;
        } Trdstramdata[31:0] = 0x0;
    } Trdstramdata @ 0x40;
    reg {
        regwidth = 0x20;

        field {
            sw = rw;
            hw = r;
        } Data[31:0] = 0x0;
    } TrDstSinkScratchLo @ 0xFF8;
    reg {
        regwidth = 0x20;

        field {
            sw = rw;
            hw = r;
        } Data[31:0] = 0x0;
    } TrDstSinkScratchHi @ 0xFFC;

    // ---------------------------------------------------------------------
    // Trace-funnel MMRs     (mmrs.sv block 1, FUNNEL_BLK_IDX)
    // ---------------------------------------------------------------------
    reg {
        regwidth = 0x20;

        field {
            sw = rw;
            hw = rw;
        } Trfunnelactive[0:0] = 0x0;
        field {
            sw = rw;
            hw = rw;
        } Trfunnelenable[1:1] = 0x0;
        field {
            sw = r;
            hw = w;
        } Trfunnelempty[3:3] = 0x1;
    } Trfunnelcontrol @ 0x1000;
    reg {
        regwidth = 0x20;

        field {
            sw = r;
            hw = r;
        } Trfunnelvermajor[3:0] = 0x1;
        field {
            sw = r;
            hw = r;
            desc = "e";
        } Trfunnelverminor[7:4] = 0x0;
        field {
            sw = r;
            hw = r;
        } Trfunnelcomptype[11:8] = 0x8;
    } Trfunnelimpl @ 0x1004;
    reg {
        regwidth = 0x20;

        field {
            sw = rw;
            hw = rw;
            desc = "Bits 7:0 are reserved for N-trace srcs and 15:8 for Dst sources";
        } Trfunneldisinput[15:0] = 0x0;
    } Trfunneldisinput @ 0x1008;
    reg {
        regwidth = 0x20;

        field {
            sw = rw;
            hw = r;
        } Data[31:0] = 0x0;
    } TrFunnelScratchLo @ 0x1FF8;
    reg {
        regwidth = 0x20;

        field {
            sw = rw;
            hw = r;
        } Data[31:0] = 0x0;
    } TrFunnelScratchHi @ 0x1FFC;

    // ---------------------------------------------------------------------
    // Core Logic Analyzer   (mmrs.sv block 2, CLA_START_IDX)
    // ---------------------------------------------------------------------
    reg {
        desc = "Configure CLA counter0. One of the 4 counters used for counting cycles after a event match, and trigger a action on match.";
        regwidth = 0x40;

        field {
            sw = r;
            hw = w;
        } Counter[15:0] = 0x0;
        field {
            sw = rw;
            hw = r;
        } Target[31:16] = 0x0;
        field {
            sw = rw;
            hw = r;
            desc = "When Counter = {upper_target,target} reset to 0.  With this bit set, counter will provide a periodic tick w/ frequency of (target +1) if the action is set to Auto Incr. The periodic tick will continue till Stop Auto Incr or Clear Counter action.";
        } ResetOnTarget[32:32] = 0x0;
        field {
            sw = r;
            hw = w;
        } UpperCounter[47:33] = 0x0;
        field {
            sw = rw;
            hw = r;
        } UpperTarget[62:48] = 0x0;
        field {
            sw = r;
            hw = r;
        } Rsvd[63:63] = 0x0;
    } CDbgClaCounter0Cfg @ 0x2100;
    reg {
        desc = "Configure CLA counter1. One of the 4 counters used for counting cycles after a event match, and trigger a action on match.";
        regwidth = 0x40;

        field {
            sw = r;
            hw = w;
        } Counter[15:0] = 0x0;
        field {
            sw = rw;
            hw = r;
        } Target[31:16] = 0x0;
        field {
            sw = rw;
            hw = r;
            desc = "When Counter = {upper_targe,target}, reset to 0.  With this bit set, counter will provide a periodic tick w/ frequency of (target +1) if the action is set to Auto Incr. The periodic tick will continue till Stop Auto Incr or Clear Counter action.";
        } ResetOnTarget[32:32] = 0x0;
        field {
            sw = r;
            hw = w;
        } UpperCounter[47:33] = 0x0;
        field {
            sw = rw;
            hw = r;
        } UpperTarget[62:48] = 0x0;
        field {
            sw = r;
            hw = r;
        } Rsvd[63:63] = 0x0;
    } CDbgClaCounter1Cfg @ 0x2108;
    reg {
        desc = "Configure CLA counter2. One of the 4 counters used for counting cycles after a event match, and trigger a action on match.";
        regwidth = 0x40;

        field {
            sw = r;
            hw = w;
        } Counter[15:0] = 0x0;
        field {
            sw = rw;
            hw = r;
        } Target[31:16] = 0x0;
        field {
            sw = rw;
            hw = r;
            desc = "When Counter = {upper_target,target}, reset to 0.  With this bit set, counter will provide a periodic tick w/ frequency of (target +1) if the action is set to Auto Incr. The periodic tick will continue till Stop Auto Incr or Clear Counter action.";
        } ResetOnTarget[32:32] = 0x0;
        field {
            sw = r;
            hw = w;
        } UpperCounter[47:33] = 0x0;
        field {
            sw = rw;
            hw = r;
        } UpperTarget[62:48] = 0x0;
        field {
            sw = r;
            hw = r;
        } Rsvd[63:63] = 0x0;
    } CDbgClaCounter2Cfg @ 0x2110;
    reg {
        desc = "Configure CLA counter3. One of the 4 counters used for counting cycles after a event match, and trigger a action on match.";
        regwidth = 0x40;

        field {
            sw = r;
            hw = w;
        } Counter[15:0] = 0x0;
        field {
            sw = rw;
            hw = r;
        } Target[31:16] = 0x0;
        field {
            sw = rw;
            hw = r;
            desc = "When Counter = {upper_target,target}, reset to 0.  With this bit set, counter will provide a periodic tick w/ frequency of (target +1) if the action is set to Auto Incr. The periodic tick will continue till Stop Auto Incr or Clear Counter action.";
        } ResetOnTarget[32:32] = 0x0;
        field {
            sw = r;
            hw = w;
        } UpperCounter[47:33] = 0x0;
        field {
            sw = rw;
            hw = r;
        } UpperTarget[62:48] = 0x0;
        field {
            sw = r;
            hw = r;
        } Rsvd[63:63] = 0x0;
    } CDbgClaCounter3Cfg @ 0x2118;
    reg {
        desc = "CLA Action(s) are tied to events(s) using \\\"event-action pairing\\\" registers. One of he 8 EAPs (Two EAPs per Node).";
        regwidth = 0x40;

        field {
            sw = rw;
            hw = r;
            desc = "Select Destination Node";
        } DestNode[1:0] = 0x0;
        field {
            sw = rw;
            hw = r;
            desc = "Select an Action";
        } Action0[7:2] = 0x0;
        field {
            sw = rw;
            hw = r;
            desc = "Select an Action";
        } Action1[13:8] = 0x0;
        field {
            sw = rw;
            hw = r;
            desc = "Relation to be satisfied among events to activate the actions";
        } LogicalOp[15:14] = 0x0;
        field {
            sw = rw;
            hw = r;
            desc = "Select a trigger event";
        } EventType0[21:16] = 0x0;
        field {
            sw = rw;
            hw = r;
            desc = "Select a trigger event";
        } EventType1[27:22] = 0x0;
        field {
            sw = rw;
            hw = r;
            desc = "Select the bit position of custom action bus to be set when EAP trigger is met. External blocks can define and implement the specific action for a given bit.";
        } CustomAction0[31:28] = 0x0;
        field {
            sw = rw;
            hw = r;
            desc = "Select the bit position of custom action bus to be set when EAP trigger is met. External blocks can define and implement the specific action for a given bit.";
        } CustomAction1[35:32] = 0x0;
        field {
            sw = rw;
            hw = r;
            desc = "custom_action0 is valid only if custom_action0_enable is set";
        } CustomAction0Enable[36:36] = 0x0;
        field {
            sw = rw;
            hw = r;
            desc = "custom_action1 is valid only if custom_action1_enable is set";
        } CustomAction1Enable[37:37] = 0x0;
        field {
            sw = rw;
            hw = r;
            desc = "Select a trigger event";
        } EventType2[43:38] = 0x0;
        field {
            sw = rw;
            hw = r;
            desc = "User Defined Function with event type 0, 1, and 2 as arguments";
        } Udf[51:44] = 0x0;
        field {
            sw = rw;
            hw = r;
        } Action2[57:52] = 0x0;
        field {
            sw = rw;
            hw = r;
        } Action3[63:58] = 0x0;
    } CDbgNode0Eap0 @ 0x2120;
    reg {
        desc = "CLA Action(s) are tied to events(s) using \\\"event-action pairing\\\" registers. One of he 8 EAPs (Two EAPs per Node).";
        regwidth = 0x40;

        field {
            sw = rw;
            hw = r;
            desc = "Select Destination Node";
        } DestNode[1:0] = 0x0;
        field {
            sw = rw;
            hw = r;
            desc = "Select an Action";
        } Action0[7:2] = 0x0;
        field {
            sw = rw;
            hw = r;
            desc = "Select an Action";
        } Action1[13:8] = 0x0;
        field {
            sw = rw;
            hw = r;
            desc = "Relation to be satisfied among events to activate the actions";
        } LogicalOp[15:14] = 0x0;
        field {
            sw = rw;
            hw = r;
            desc = "Select a trigger event";
        } EventType0[21:16] = 0x0;
        field {
            sw = rw;
            hw = r;
            desc = "Select a trigger event";
        } EventType1[27:22] = 0x0;
        field {
            sw = rw;
            hw = r;
            desc = "Select the bit position of custom action bus to be set when EAP trigger is met. External blocks can define and implement the specific action for a given bit.";
        } CustomAction0[31:28] = 0x0;
        field {
            sw = rw;
            hw = r;
            desc = "Select the bit position of custom action bus to be set when EAP trigger is met. External blocks can define and implement the specific action for a given bit.";
        } CustomAction1[35:32] = 0x0;
        field {
            sw = rw;
            hw = r;
            desc = "custom_action0 is valid only if custom_action0_enable is set";
        } CustomAction0Enable[36:36] = 0x0;
        field {
            sw = rw;
            hw = r;
            desc = "custom_action1 is valid only if custom_action1_enable is set";
        } CustomAction1Enable[37:37] = 0x0;
        field {
            sw = rw;
            hw = r;
            desc = "Select a trigger event";
        } EventType2[43:38] = 0x0;
        field {
            sw = rw;
            hw = r;
            desc = "User Defined Function with event type 0, 1, and 2 as arguments";
        } Udf[51:44] = 0x0;
        field {
            sw = rw;
            hw = r;
        } Action2[57:52] = 0x0;
        field {
            sw = rw;
            hw = r;
        } Action3[63:58] = 0x0;
    } CDbgNode0Eap1 @ 0x2128;
    reg {
        desc = "CLA Action(s) are tied to events(s) using \\\"event-action pairing\\\" registers. One of he 8 EAPs (Two EAPs per Node).";
        regwidth = 0x40;

        field {
            sw = rw;
            hw = r;
            desc = "Select Destination Node";
        } DestNode[1:0] = 0x0;
        field {
            sw = rw;
            hw = r;
            desc = "Select an Action";
        } Action0[7:2] = 0x0;
        field {
            sw = rw;
            hw = r;
            desc = "Select an Action";
        } Action1[13:8] = 0x0;
        field {
            sw = rw;
            hw = r;
            desc = "Relation to be satisfied among events to activate the actions";
        } LogicalOp[15:14] = 0x0;
        field {
            sw = rw;
            hw = r;
            desc = "Select a trigger event";
        } EventType0[21:16] = 0x0;
        field {
            sw = rw;
            hw = r;
            desc = "Select a trigger event";
        } EventType1[27:22] = 0x0;
        field {
            sw = rw;
            hw = r;
            desc = "Select the bit position of custom action bus to be set when EAP trigger is met. External blocks can define and implement the specific action for a given bit.";
        } CustomAction0[31:28] = 0x0;
        field {
            sw = rw;
            hw = r;
            desc = "Select the bit position of custom action bus to be set when EAP trigger is met. External blocks can define and implement the specific action for a given bit.";
        } CustomAction1[35:32] = 0x0;
        field {
            sw = rw;
            hw = r;
            desc = "custom_action0 is valid only if custom_action0_enable is set";
        } CustomAction0Enable[36:36] = 0x0;
        field {
            sw = rw;
            hw = r;
            desc = "custom_action1 is valid only if custom_action1_enable is set";
        } CustomAction1Enable[37:37] = 0x0;
        field {
            sw = rw;
            hw = r;
            desc = "Select a trigger event";
        } EventType2[43:38] = 0x0;
        field {
            sw = rw;
            hw = r;
            desc = "User Defined Function with event type 0, 1, and 2 as arguments";
        } Udf[51:44] = 0x0;
        field {
            sw = rw;
            hw = r;
        } Action2[57:52] = 0x0;
        field {
            sw = rw;
            hw = r;
        } Action3[63:58] = 0x0;
    } CDbgNode1Eap0 @ 0x2130;
    reg {
        desc = "CLA Action(s) are tied to events(s) using \\\"event-action pairing\\\" registers. One of he 8 EAPs (Two EAPs per Node).";
        regwidth = 0x40;

        field {
            sw = rw;
            hw = r;
            desc = "Select Destination Node";
        } DestNode[1:0] = 0x0;
        field {
            sw = rw;
            hw = r;
            desc = "Select an Action";
        } Action0[7:2] = 0x0;
        field {
            sw = rw;
            hw = r;
            desc = "Select an Action";
        } Action1[13:8] = 0x0;
        field {
            sw = rw;
            hw = r;
            desc = "Relation to be satisfied among events to activate the actions";
        } LogicalOp[15:14] = 0x0;
        field {
            sw = rw;
            hw = r;
            desc = "Select a trigger event";
        } EventType0[21:16] = 0x0;
        field {
            sw = rw;
            hw = r;
            desc = "Select a trigger event";
        } EventType1[27:22] = 0x0;
        field {
            sw = rw;
            hw = r;
            desc = "Select the bit position of custom action bus to be set when EAP trigger is met. External blocks can define and implement the specific action for a given bit.";
        } CustomAction0[31:28] = 0x0;
        field {
            sw = rw;
            hw = r;
            desc = "Select the bit position of custom action bus to be set when EAP trigger is met. External blocks can define and implement the specific action for a given bit.";
        } CustomAction1[35:32] = 0x0;
        field {
            sw = rw;
            hw = r;
            desc = "custom_action0 is valid only if custom_action0_enable is set";
        } CustomAction0Enable[36:36] = 0x0;
        field {
            sw = rw;
            hw = r;
            desc = "custom_action1 is valid only if custom_action1_enable is set";
        } CustomAction1Enable[37:37] = 0x0;
        field {
            sw = rw;
            hw = r;
            desc = "Select a trigger event";
        } EventType2[43:38] = 0x0;
        field {
            sw = rw;
            hw = r;
            desc = "User Defined Function with event type 0, 1, and 2 as arguments";
        } Udf[51:44] = 0x0;
        field {
            sw = rw;
            hw = r;
        } Action2[57:52] = 0x0;
        field {
            sw = rw;
            hw = r;
        } Action3[63:58] = 0x0;
    } CDbgNode1Eap1 @ 0x2138;
    reg {
        desc = "CLA Action(s) are tied to events(s) using \\\"event-action pairing\\\" registers. One of he 8 EAPs (Two EAPs per Node).";
        regwidth = 0x40;

        field {
            sw = rw;
            hw = r;
            desc = "Select Destination Node";
        } DestNode[1:0] = 0x0;
        field {
            sw = rw;
            hw = r;
            desc = "Select an Action";
        } Action0[7:2] = 0x0;
        field {
            sw = rw;
            hw = r;
            desc = "Select an Action";
        } Action1[13:8] = 0x0;
        field {
            sw = rw;
            hw = r;
            desc = "Relation to be satisfied among events to activate the actions";
        } LogicalOp[15:14] = 0x0;
        field {
            sw = rw;
            hw = r;
            desc = "Select a trigger event";
        } EventType0[21:16] = 0x0;
        field {
            sw = rw;
            hw = r;
            desc = "Select a trigger event";
        } EventType1[27:22] = 0x0;
        field {
            sw = rw;
            hw = r;
            desc = "Select the bit position of custom action bus to be set when EAP trigger is met. External blocks can define and implement the specific action for a given bit.";
        } CustomAction0[31:28] = 0x0;
        field {
            sw = rw;
            hw = r;
            desc = "Select the bit position of custom action bus to be set when EAP trigger is met. External blocks can define and implement the specific action for a given bit.";
        } CustomAction1[35:32] = 0x0;
        field {
            sw = rw;
            hw = r;
            desc = "custom_action0 is valid only if custom_action0_enable is set";
        } CustomAction0Enable[36:36] = 0x0;
        field {
            sw = rw;
            hw = r;
            desc = "custom_action1 is valid only if custom_action1_enable is set";
        } CustomAction1Enable[37:37] = 0x0;
        field {
            sw = rw;
            hw = r;
            desc = "Select a trigger event";
        } EventType2[43:38] = 0x0;
        field {
            sw = rw;
            hw = r;
            desc = "User Defined Function with event type 0, 1, and 2 as arguments";
        } Udf[51:44] = 0x0;
        field {
            sw = rw;
            hw = r;
        } Action2[57:52] = 0x0;
        field {
            sw = rw;
            hw = r;
        } Action3[63:58] = 0x0;
    } CDbgNode2Eap0 @ 0x2140;
    reg {
        desc = "CLA Action(s) are tied to events(s) using \\\"event-action pairing\\\" registers. One of he 8 EAPs (Two EAPs per Node).";
        regwidth = 0x40;

        field {
            sw = rw;
            hw = r;
            desc = "Select Destination Node";
        } DestNode[1:0] = 0x0;
        field {
            sw = rw;
            hw = r;
            desc = "Select an Action";
        } Action0[7:2] = 0x0;
        field {
            sw = rw;
            hw = r;
            desc = "Select an Action";
        } Action1[13:8] = 0x0;
        field {
            sw = rw;
            hw = r;
            desc = "Relation to be satisfied among events to activate the actions";
        } LogicalOp[15:14] = 0x0;
        field {
            sw = rw;
            hw = r;
            desc = "Select a trigger event";
        } EventType0[21:16] = 0x0;
        field {
            sw = rw;
            hw = r;
            desc = "Select a trigger event";
        } EventType1[27:22] = 0x0;
        field {
            sw = rw;
            hw = r;
            desc = "Select the bit position of custom action bus to be set when EAP trigger is met. External blocks can define and implement the specific action for a given bit.";
        } CustomAction0[31:28] = 0x0;
        field {
            sw = rw;
            hw = r;
            desc = "Select the bit position of custom action bus to be set when EAP trigger is met. External blocks can define and implement the specific action for a given bit.";
        } CustomAction1[35:32] = 0x0;
        field {
            sw = rw;
            hw = r;
            desc = "custom_action0 is valid only if custom_action0_enable is set";
        } CustomAction0Enable[36:36] = 0x0;
        field {
            sw = rw;
            hw = r;
            desc = "custom_action1 is valid only if custom_action1_enable is set";
        } CustomAction1Enable[37:37] = 0x0;
        field {
            sw = rw;
            hw = r;
            desc = "Select a trigger event";
        } EventType2[43:38] = 0x0;
        field {
            sw = rw;
            hw = r;
            desc = "User Defined Function with event type 0, 1, and 2 as arguments";
        } Udf[51:44] = 0x0;
        field {
            sw = rw;
            hw = r;
        } Action2[57:52] = 0x0;
        field {
            sw = rw;
            hw = r;
        } Action3[63:58] = 0x0;
    } CDbgNode2Eap1 @ 0x2148;
    reg {
        desc = "CLA Action(s) are tied to events(s) using \\\"event-action pairing\\\" registers. One of he 8 EAPs (Two EAPs per Node).";
        regwidth = 0x40;

        field {
            sw = rw;
            hw = r;
            desc = "Select Destination Node";
        } DestNode[1:0] = 0x0;
        field {
            sw = rw;
            hw = r;
            desc = "Select an Action";
        } Action0[7:2] = 0x0;
        field {
            sw = rw;
            hw = r;
            desc = "Select an Action";
        } Action1[13:8] = 0x0;
        field {
            sw = rw;
            hw = r;
            desc = "Relation to be satisfied among events to activate the actions";
        } LogicalOp[15:14] = 0x0;
        field {
            sw = rw;
            hw = r;
            desc = "Select a trigger event";
        } EventType0[21:16] = 0x0;
        field {
            sw = rw;
            hw = r;
            desc = "Select a trigger event";
        } EventType1[27:22] = 0x0;
        field {
            sw = rw;
            hw = r;
            desc = "Select the bit position of custom action bus to be set when EAP trigger is met. External blocks can define and implement the specific action for a given bit.";
        } CustomAction0[31:28] = 0x0;
        field {
            sw = rw;
            hw = r;
            desc = "Select the bit position of custom action bus to be set when EAP trigger is met. External blocks can define and implement the specific action for a given bit.";
        } CustomAction1[35:32] = 0x0;
        field {
            sw = rw;
            hw = r;
            desc = "custom_action0 is valid only if custom_action0_enable is set";
        } CustomAction0Enable[36:36] = 0x0;
        field {
            sw = rw;
            hw = r;
            desc = "custom_action1 is valid only if custom_action1_enable is set";
        } CustomAction1Enable[37:37] = 0x0;
        field {
            sw = rw;
            hw = r;
            desc = "Select a trigger event";
        } EventType2[43:38] = 0x0;
        field {
            sw = rw;
            hw = r;
            desc = "User Defined Function with event type 0, 1, and 2 as arguments";
        } Udf[51:44] = 0x0;
        field {
            sw = rw;
            hw = r;
        } Action2[57:52] = 0x0;
        field {
            sw = rw;
            hw = r;
        } Action3[63:58] = 0x0;
    } CDbgNode3Eap0 @ 0x2150;
    reg {
        desc = "CLA Action(s) are tied to events(s) using \\\"event-action pairing\\\" registers. One of he 8 EAPs (Two EAPs per Node).";
        regwidth = 0x40;

        field {
            sw = rw;
            hw = r;
            desc = "Select Destination Node";
        } DestNode[1:0] = 0x0;
        field {
            sw = rw;
            hw = r;
            desc = "Select an Action";
        } Action0[7:2] = 0x0;
        field {
            sw = rw;
            hw = r;
            desc = "Select an Action";
        } Action1[13:8] = 0x0;
        field {
            sw = rw;
            hw = r;
            desc = "Relation to be satisfied among events to activate the actions";
        } LogicalOp[15:14] = 0x0;
        field {
            sw = rw;
            hw = r;
            desc = "Select a trigger event";
        } EventType0[21:16] = 0x0;
        field {
            sw = rw;
            hw = r;
            desc = "Select a trigger event";
        } EventType1[27:22] = 0x0;
        field {
            sw = rw;
            hw = r;
            desc = "Select the bit position of custom action bus to be set when EAP trigger is met. External blocks can define and implement the specific action for a given bit.";
        } CustomAction0[31:28] = 0x0;
        field {
            sw = rw;
            hw = r;
            desc = "Select the bit position of custom action bus to be set when EAP trigger is met. External blocks can define and implement the specific action for a given bit.";
        } CustomAction1[35:32] = 0x0;
        field {
            sw = rw;
            hw = r;
            desc = "custom_action0 is valid only if custom_action0_enable is set";
        } CustomAction0Enable[36:36] = 0x0;
        field {
            sw = rw;
            hw = r;
            desc = "custom_action1 is valid only if custom_action1_enable is set";
        } CustomAction1Enable[37:37] = 0x0;
        field {
            sw = rw;
            hw = r;
            desc = "Select a trigger event";
        } EventType2[43:38] = 0x0;
        field {
            sw = rw;
            hw = r;
            desc = "User Defined Function with event type 0, 1, and 2 as arguments";
        } Udf[51:44] = 0x0;
        field {
            sw = rw;
            hw = r;
        } Action2[57:52] = 0x0;
        field {
            sw = rw;
            hw = r;
        } Action3[63:58] = 0x0;
    } CDbgNode3Eap1 @ 0x2158;
    reg {
        regwidth = 0x40;

        field {
            sw = rw;
            hw = r;
        } Value[63:0] = 0x0;
    } CDbgSignalMask0Lo @ 0x2160;
    reg {
        regwidth = 0x40;

        field {
            sw = rw;
            hw = r;
        } Value[63:0] = 0x0;
    } CDbgSignalMatch0Lo @ 0x2168;
    reg {
        regwidth = 0x40;

        field {
            sw = rw;
            hw = r;
        } Value[63:0] = 0x0;
    } CDbgSignalMask1Lo @ 0x2170;
    reg {
        regwidth = 0x40;

        field {
            sw = rw;
            hw = r;
        } Value[63:0] = 0x0;
    } CDbgSignalMatch1Lo @ 0x2178;
    reg {
        desc = "Register to configure debug bus for edge triggers.";
        regwidth = 0x40;

        field {
            sw = rw;
            hw = r;
            desc = "Define which signal to select for edge detection.";
        } Signal0Select[6:0] = 0x0;
        field {
            sw = rw;
            hw = r;
            desc = "Defines which edge to detect for signal from signal0_select. 1: Pos edge, 0: Neg Edge";
        } PosEdgeSignal0[7:7] = 0x0;
        field {
            sw = rw;
            hw = r;
            desc = "Define which signal to select for edge detection.";
        } Signal1Select[14:8] = 0x0;
        field {
            sw = rw;
            hw = r;
            desc = "Defines which edge to detect for signal from signal1_select. 1: Pos edge, 0: Neg Edge";
        } PosEdgeSignal1[15:15] = 0x0;
    } CDbgSignalEdgeDetectCfg @ 0x2180;
    reg {
        desc = "Register to indicate if EAP Pair was activated. Use the corresponding w2c register to reset the status. There are 2 bits for each EAP. The bit corresponds to action-0 and action-1 of the EAP. The register is used by SW to know if an action was taken (ex: NMI ISR needs to know which of the EAP triggered the NMI)";
        regwidth = 0x40;

        field {
            sw = r;
            hw = w;
        } Node0Eap0[0:0] = 0x0;
        field {
            sw = r;
            hw = w;
        } Node0Eap1[1:1] = 0x0;
        field {
            sw = r;
            hw = w;
        } Node0Eap2[2:2] = 0x0;
        field {
            sw = r;
            hw = w;
        } Node0Eap3[3:3] = 0x0;
        field {
            sw = r;
            hw = w;
        } Node1Eap0[4:4] = 0x0;
        field {
            sw = r;
            hw = w;
        } Node1Eap1[5:5] = 0x0;
        field {
            sw = r;
            hw = w;
        } Node1Eap2[6:6] = 0x0;
        field {
            sw = r;
            hw = w;
        } Node1Eap3[7:7] = 0x0;
        field {
            sw = r;
            hw = w;
        } Node2Eap0[8:8] = 0x0;
        field {
            sw = r;
            hw = w;
        } Node2Eap1[9:9] = 0x0;
        field {
            sw = r;
            hw = w;
        } Node2Eap2[10:10] = 0x0;
        field {
            sw = r;
            hw = w;
        } Node2Eap3[11:11] = 0x0;
        field {
            sw = r;
            hw = w;
        } Node3Eap0[12:12] = 0x0;
        field {
            sw = r;
            hw = w;
        } Node3Eap1[13:13] = 0x0;
        field {
            sw = r;
            hw = w;
        } Node3Eap2[14:14] = 0x0;
        field {
            sw = r;
            hw = w;
        } Node3Eap3[15:15] = 0x0;
        field {
            sw = r;
            hw = w;
        } Rsvd3116[31:16] = 0x0;
        field {
            sw = rw;
            hw = rw;
        } Node0Eap0W2C[32:32] = 0x0;
        field {
            sw = rw;
            hw = rw;
        } Node0Eap1W2C[33:33] = 0x0;
        field {
            sw = rw;
            hw = rw;
        } Node0Eap2W2C[34:34] = 0x0;
        field {
            sw = rw;
            hw = rw;
        } Node0Eap3W2C[35:35] = 0x0;
        field {
            sw = rw;
            hw = rw;
        } Node1Eap0W2C[36:36] = 0x0;
        field {
            sw = rw;
            hw = rw;
        } Node1Eap1W2C[37:37] = 0x0;
        field {
            sw = rw;
            hw = rw;
        } Node1Eap2W2C[38:38] = 0x0;
        field {
            sw = rw;
            hw = rw;
        } Node1Eap3W2C[39:39] = 0x0;
        field {
            sw = rw;
            hw = rw;
        } Node2Eap0W2C[40:40] = 0x0;
        field {
            sw = rw;
            hw = rw;
        } Node2Eap1W2C[41:41] = 0x0;
        field {
            sw = rw;
            hw = rw;
        } Node2Eap2W2C[42:42] = 0x0;
        field {
            sw = rw;
            hw = rw;
        } Node2Eap3W2C[43:43] = 0x0;
        field {
            sw = rw;
            hw = rw;
        } Node3Eap0W2C[44:44] = 0x0;
        field {
            sw = rw;
            hw = rw;
        } Node3Eap1W2C[45:45] = 0x0;
        field {
            sw = rw;
            hw = rw;
        } Node3Eap2W2C[46:46] = 0x0;
        field {
            sw = rw;
            hw = rw;
        } Node3Eap3W2C[47:47] = 0x0;
    } CDbgEapStatus @ 0x2188;
    reg {
        desc = "Ctrl/Status register to Enable EAP after EAP programming is complete, and read the current node.";
        regwidth = 0x40;

        field {
            sw = r;
            hw = w;
            desc = "Read the current node.";
        } CurrentNode[1:0] = 0x0;
        field {
            sw = rw;
            hw = r;
            desc = "Set Enable EAP to 1 after EAP programming is complete";
        } EnableEap[5:5] = 0x0;
        field {
            sw = rw;
            hw = r;
            desc = "Set this bit to 1 to enable CLA. If this bit is set, CLA is clock gated (save pwr)";
        } EnableCla[6:6] = 0x0;
        field {
            sw = rw;
            hw = r;
            desc = "Creates a window in which we don’t forward the incoming Xtrigger and Clock_Halt signal";
        } ClaChainLoopDelay[13:7] = 0x36;
        field {
            sw = rw;
            hw = r;
            desc = "If this bit is set, clock halt action is not applied to global clocks";
        } DisableGlobalClockHalt[14:14] = 0x0;
        field {
            sw = rw;
            hw = r;
            desc = "If this bit is set, clock halt action is not applied to local clocks";
        } DisableLocalClockHalt[15:15] = 0x0;
        field {
            sw = rw;
            hw = r;
        } Rsvd6216[62:16] = 0x0;
        field {
            sw = rw;
            hw = r;
        } ClaLock[63:63] = 0x0;
    } CDbgClaCtrlStatus @ 0x2190;
    reg {
        regwidth = 0x40;

        field {
            sw = rw;
            hw = r;
        } Dbmmode[1:0] = 0x0;
        field {
            sw = rw;
            hw = r;
        } Dbmid[7:2] = 0x0;
        field {
            sw = rw;
            hw = r;
        } Finegraintime[8:8] = 0x0;
        field {
            sw = rw;
            hw = r;
        } Rsvd159[15:9] = 0x0;
        field {
            sw = rw;
            hw = r;
        } Muxselseg0[21:16] = 0x0;
        field {
            sw = rw;
            hw = r;
        } Muxselseg1[27:22] = 0x0;
        field {
            sw = rw;
            hw = r;
        } Muxselseg2[33:28] = 0x0;
        field {
            sw = rw;
            hw = r;
        } Muxselseg3[39:34] = 0x0;
        field {
            sw = rw;
            hw = r;
        } Muxselseg4[45:40] = 0x0;
        field {
            sw = rw;
            hw = r;
        } Muxselseg5[51:46] = 0x0;
        field {
            sw = rw;
            hw = r;
        } Muxselseg6[57:52] = 0x0;
        field {
            sw = rw;
            hw = r;
        } Muxselseg7[63:58] = 0x0;
    } CDbgMuxSelLo @ 0x2198;
    reg {
        desc = "Reserved Register that can be changed.";
        regwidth = 0x40;

        field {
            sw = rw;
            hw = r;
            desc = "Value of reserved register.";
        } Value[63:0] = 0x0;
    } CDbgRsvd1 @ 0x21A0;
    reg {
        desc = "Reserved Register that can be changed.";
        regwidth = 0x40;

        field {
            sw = rw;
            hw = r;
            desc = "Value of reserved register.";
        } Value[63:0] = 0x0;
    } CDbgRsvd2 @ 0x21A8;
    reg {
        regwidth = 0x40;

        field {
            sw = rw;
            hw = r;
        } Value[63:0] = 0x0;
    } CDbgTransitionMaskLo @ 0x21B0;
    reg {
        regwidth = 0x40;

        field {
            sw = rw;
            hw = r;
        } Value[63:0] = 0x0;
    } CDbgTransitionFromValueLo @ 0x21B8;
    reg {
        regwidth = 0x40;

        field {
            sw = rw;
            hw = r;
        } Value[63:0] = 0x0;
    } CDbgTransitionToValueLo @ 0x21C0;
    reg {
        regwidth = 0x40;

        field {
            sw = rw;
            hw = r;
        } Value[63:0] = 0x0;
    } CDbgOnesCountMaskLo @ 0x21C8;
    reg {
        desc = "2 registers to configure \\\"ones count\\\" event. Event triggered when the sum of the signals match the value specified in this register.";
        regwidth = 0x40;

        field {
            sw = rw;
            hw = r;
        } Value[63:0] = 0x0;
    } CDbgOnesCountValue @ 0x21D0;
    reg {
        regwidth = 0x40;

        field {
            sw = rw;
            hw = r;
        } Mask[63:0] = 0x0;
    } CDbgAnyChangeLo @ 0x21D8;
    reg {
        regwidth = 0x40;

        field {
            sw = r;
            hw = w;
        } Value[63:0] = 0x0;
    } CDbgSignalSnapshotNode0Eap0Lo @ 0x21E0;
    reg {
        regwidth = 0x40;

        field {
            sw = r;
            hw = w;
        } Value[63:0] = 0x0;
    } CDbgSignalSnapshotNode0Eap1Lo @ 0x21E8;
    reg {
        regwidth = 0x40;

        field {
            sw = r;
            hw = w;
        } Value[63:0] = 0x0;
    } CDbgSignalSnapshotNode1Eap0Lo @ 0x21F0;
    reg {
        regwidth = 0x40;

        field {
            sw = r;
            hw = w;
        } Value[63:0] = 0x0;
    } CDbgSignalSnapshotNode1Eap1Lo @ 0x21F8;
    reg {
        regwidth = 0x40;

        field {
            sw = r;
            hw = w;
        } Value[63:0] = 0x0;
    } CDbgSignalSnapshotNode2Eap0Lo @ 0x2200;
    reg {
        regwidth = 0x40;

        field {
            sw = r;
            hw = w;
        } Value[63:0] = 0x0;
    } CDbgSignalSnapshotNode2Eap1Lo @ 0x2208;
    reg {
        regwidth = 0x40;

        field {
            sw = r;
            hw = w;
        } Value[63:0] = 0x0;
    } CDbgSignalSnapshotNode3Eap0Lo @ 0x2210;
    reg {
        regwidth = 0x40;

        field {
            sw = r;
            hw = w;
        } Value[63:0] = 0x0;
    } CDbgSignalSnapshotNode3Eap1Lo @ 0x2218;
    reg {
        desc = "This value is compared (greater than or equal to the programmed value) against the internal time register value of the core, and is used to generate a time match event for CLA. Needs to be non zero for the time match event signal to trigger. The event will only trigger an action if the EAP programming is done. Requires writing 0 to this register to stop the match event.";
        regwidth = 0x40;

        field {
            sw = rw;
            hw = r;
        } TimeMatchVal[63:0] = 0x0;
    } CDbgClaTimeMatch @ 0x2220;
    reg {
        regwidth = 0x40;

        field {
            sw = rw;
            hw = r;
        } Value[63:0] = 0x0;
    } CDbgSignalMask2Lo @ 0x2228;
    reg {
        regwidth = 0x40;

        field {
            sw = rw;
            hw = r;
        } Value[63:0] = 0x0;
    } CDbgSignalMatch2Lo @ 0x2230;
    reg {
        regwidth = 0x40;

        field {
            sw = rw;
            hw = r;
        } Value[63:0] = 0x0;
    } CDbgSignalMask3Lo @ 0x2238;
    reg {
        regwidth = 0x40;

        field {
            sw = rw;
            hw = r;
        } Value[63:0] = 0x0;
    } CDbgSignalMatch3Lo @ 0x2240;
    reg {
        desc = "CLA Action(s) are tied to events(s) using \\\"event-action pairing\\\" registers. One of he 8 EAPs (4 EAPs per Node).";
        regwidth = 0x40;

        field {
            sw = rw;
            hw = r;
            desc = "Select Destination Node";
        } DestNode[1:0] = 0x0;
        field {
            sw = rw;
            hw = r;
            desc = "Select an Action";
        } Action0[7:2] = 0x0;
        field {
            sw = rw;
            hw = r;
            desc = "Select an Action";
        } Action1[13:8] = 0x0;
        field {
            sw = rw;
            hw = r;
            desc = "Relation to be satisfied among events to activate the actions";
        } LogicalOp[15:14] = 0x0;
        field {
            sw = rw;
            hw = r;
            desc = "Select a trigger event";
        } EventType0[21:16] = 0x0;
        field {
            sw = rw;
            hw = r;
            desc = "Select a trigger event";
        } EventType1[27:22] = 0x0;
        field {
            sw = rw;
            hw = r;
            desc = "Select the bit position of custom action bus to be set when EAP trigger is met. External blocks can define and implement the specific action for a given bit.";
        } CustomAction0[31:28] = 0x0;
        field {
            sw = rw;
            hw = r;
            desc = "Select the bit position of custom action bus to be set when EAP trigger is met. External blocks can define and implement the specific action for a given bit.";
        } CustomAction1[35:32] = 0x0;
        field {
            sw = rw;
            hw = r;
            desc = "custom_action0 is valid only if custom_action0_enable is set";
        } CustomAction0Enable[36:36] = 0x0;
        field {
            sw = rw;
            hw = r;
            desc = "custom_action1 is valid only if custom_action1_enable is set";
        } CustomAction1Enable[37:37] = 0x0;
        field {
            sw = rw;
            hw = r;
            desc = "Select a trigger event";
        } EventType2[43:38] = 0x0;
        field {
            sw = rw;
            hw = r;
            desc = "User Defined Function with event type 0, 1, and 2 as arguments";
        } Udf[51:44] = 0x0;
        field {
            sw = rw;
            hw = r;
            desc = "Select an Action";
        } Action2[57:52] = 0x0;
        field {
            sw = rw;
            hw = r;
            desc = "Select an Action";
        } Action3[63:58] = 0x0;
    } CDbgNode0Eap2 @ 0x2248;
    reg {
        desc = "CLA Action(s) are tied to events(s) using \\\"event-action pairing\\\" registers. One of he 8 EAPs (4 EAPs per Node).";
        regwidth = 0x40;

        field {
            sw = rw;
            hw = r;
            desc = "Select Destination Node";
        } DestNode[1:0] = 0x0;
        field {
            sw = rw;
            hw = r;
            desc = "Select an Action";
        } Action0[7:2] = 0x0;
        field {
            sw = rw;
            hw = r;
            desc = "Select an Action";
        } Action1[13:8] = 0x0;
        field {
            sw = rw;
            hw = r;
            desc = "Relation to be satisfied among events to activate the actions";
        } LogicalOp[15:14] = 0x0;
        field {
            sw = rw;
            hw = r;
            desc = "Select a trigger event";
        } EventType0[21:16] = 0x0;
        field {
            sw = rw;
            hw = r;
            desc = "Select a trigger event";
        } EventType1[27:22] = 0x0;
        field {
            sw = rw;
            hw = r;
            desc = "Select the bit position of custom action bus to be set when EAP trigger is met. External blocks can define and implement the specific action for a given bit.";
        } CustomAction0[31:28] = 0x0;
        field {
            sw = rw;
            hw = r;
            desc = "Select the bit position of custom action bus to be set when EAP trigger is met. External blocks can define and implement the specific action for a given bit.";
        } CustomAction1[35:32] = 0x0;
        field {
            sw = rw;
            hw = r;
            desc = "custom_action0 is valid only if custom_action0_enable is set";
        } CustomAction0Enable[36:36] = 0x0;
        field {
            sw = rw;
            hw = r;
            desc = "custom_action1 is valid only if custom_action1_enable is set";
        } CustomAction1Enable[37:37] = 0x0;
        field {
            sw = rw;
            hw = r;
            desc = "Select a trigger event";
        } EventType2[43:38] = 0x0;
        field {
            sw = rw;
            hw = r;
            desc = "User Defined Function with event type 0, 1, and 2 as arguments";
        } Udf[51:44] = 0x0;
        field {
            sw = rw;
            hw = r;
            desc = "Select an Action";
        } Action2[57:52] = 0x0;
        field {
            sw = rw;
            hw = r;
            desc = "Select an Action";
        } Action3[63:58] = 0x0;
    } CDbgNode0Eap3 @ 0x2250;
    reg {
        desc = "CLA Action(s) are tied to events(s) using \\\"event-action pairing\\\" registers. One of he 8 EAPs (4 EAPs per Node).";
        regwidth = 0x40;

        field {
            sw = rw;
            hw = r;
            desc = "Select Destination Node";
        } DestNode[1:0] = 0x0;
        field {
            sw = rw;
            hw = r;
            desc = "Select an Action";
        } Action0[7:2] = 0x0;
        field {
            sw = rw;
            hw = r;
            desc = "Select an Action";
        } Action1[13:8] = 0x0;
        field {
            sw = rw;
            hw = r;
            desc = "Relation to be satisfied among events to activate the actions";
        } LogicalOp[15:14] = 0x0;
        field {
            sw = rw;
            hw = r;
            desc = "Select a trigger event";
        } EventType0[21:16] = 0x0;
        field {
            sw = rw;
            hw = r;
            desc = "Select a trigger event";
        } EventType1[27:22] = 0x0;
        field {
            sw = rw;
            hw = r;
            desc = "Select the bit position of custom action bus to be set when EAP trigger is met. External blocks can define and implement the specific action for a given bit.";
        } CustomAction0[31:28] = 0x0;
        field {
            sw = rw;
            hw = r;
            desc = "Select the bit position of custom action bus to be set when EAP trigger is met. External blocks can define and implement the specific action for a given bit.";
        } CustomAction1[35:32] = 0x0;
        field {
            sw = rw;
            hw = r;
            desc = "custom_action0 is valid only if custom_action0_enable is set";
        } CustomAction0Enable[36:36] = 0x0;
        field {
            sw = rw;
            hw = r;
            desc = "custom_action1 is valid only if custom_action1_enable is set";
        } CustomAction1Enable[37:37] = 0x0;
        field {
            sw = rw;
            hw = r;
            desc = "Select a trigger event";
        } EventType2[43:38] = 0x0;
        field {
            sw = rw;
            hw = r;
            desc = "User Defined Function with event type 0, 1, and 2 as arguments";
        } Udf[51:44] = 0x0;
        field {
            sw = rw;
            hw = r;
            desc = "Select an Action";
        } Action2[57:52] = 0x0;
        field {
            sw = rw;
            hw = r;
            desc = "Select an Action";
        } Action3[63:58] = 0x0;
    } CDbgNode1Eap2 @ 0x2258;
    reg {
        desc = "CLA Action(s) are tied to events(s) using \\\"event-action pairing\\\" registers. One of he 8 EAPs (4 EAPs per Node).";
        regwidth = 0x40;

        field {
            sw = rw;
            hw = r;
            desc = "Select Destination Node";
        } DestNode[1:0] = 0x0;
        field {
            sw = rw;
            hw = r;
            desc = "Select an Action";
        } Action0[7:2] = 0x0;
        field {
            sw = rw;
            hw = r;
            desc = "Select an Action";
        } Action1[13:8] = 0x0;
        field {
            sw = rw;
            hw = r;
            desc = "Relation to be satisfied among events to activate the actions";
        } LogicalOp[15:14] = 0x0;
        field {
            sw = rw;
            hw = r;
            desc = "Select a trigger event";
        } EventType0[21:16] = 0x0;
        field {
            sw = rw;
            hw = r;
            desc = "Select a trigger event";
        } EventType1[27:22] = 0x0;
        field {
            sw = rw;
            hw = r;
            desc = "Select the bit position of custom action bus to be set when EAP trigger is met. External blocks can define and implement the specific action for a given bit.";
        } CustomAction0[31:28] = 0x0;
        field {
            sw = rw;
            hw = r;
            desc = "Select the bit position of custom action bus to be set when EAP trigger is met. External blocks can define and implement the specific action for a given bit.";
        } CustomAction1[35:32] = 0x0;
        field {
            sw = rw;
            hw = r;
            desc = "custom_action0 is valid only if custom_action0_enable is set";
        } CustomAction0Enable[36:36] = 0x0;
        field {
            sw = rw;
            hw = r;
            desc = "custom_action1 is valid only if custom_action1_enable is set";
        } CustomAction1Enable[37:37] = 0x0;
        field {
            sw = rw;
            hw = r;
            desc = "Select a trigger event";
        } EventType2[43:38] = 0x0;
        field {
            sw = rw;
            hw = r;
            desc = "User Defined Function with event type 0, 1, and 2 as arguments";
        } Udf[51:44] = 0x0;
        field {
            sw = rw;
            hw = r;
            desc = "Select an Action";
        } Action2[57:52] = 0x0;
        field {
            sw = rw;
            hw = r;
            desc = "Select an Action";
        } Action3[63:58] = 0x0;
    } CDbgNode1Eap3 @ 0x2260;
    reg {
        desc = "CLA Action(s) are tied to events(s) using \\\"event-action pairing\\\" registers. One of he 8 EAPs (4 EAPs per Node).";
        regwidth = 0x40;

        field {
            sw = rw;
            hw = r;
            desc = "Select Destination Node";
        } DestNode[1:0] = 0x0;
        field {
            sw = rw;
            hw = r;
            desc = "Select an Action";
        } Action0[7:2] = 0x0;
        field {
            sw = rw;
            hw = r;
            desc = "Select an Action";
        } Action1[13:8] = 0x0;
        field {
            sw = rw;
            hw = r;
            desc = "Relation to be satisfied among events to activate the actions";
        } LogicalOp[15:14] = 0x0;
        field {
            sw = rw;
            hw = r;
            desc = "Select a trigger event";
        } EventType0[21:16] = 0x0;
        field {
            sw = rw;
            hw = r;
            desc = "Select a trigger event";
        } EventType1[27:22] = 0x0;
        field {
            sw = rw;
            hw = r;
            desc = "Select the bit position of custom action bus to be set when EAP trigger is met. External blocks can define and implement the specific action for a given bit.";
        } CustomAction0[31:28] = 0x0;
        field {
            sw = rw;
            hw = r;
            desc = "Select the bit position of custom action bus to be set when EAP trigger is met. External blocks can define and implement the specific action for a given bit.";
        } CustomAction1[35:32] = 0x0;
        field {
            sw = rw;
            hw = r;
            desc = "custom_action0 is valid only if custom_action0_enable is set";
        } CustomAction0Enable[36:36] = 0x0;
        field {
            sw = rw;
            hw = r;
            desc = "custom_action1 is valid only if custom_action1_enable is set";
        } CustomAction1Enable[37:37] = 0x0;
        field {
            sw = rw;
            hw = r;
            desc = "Select a trigger event";
        } EventType2[43:38] = 0x0;
        field {
            sw = rw;
            hw = r;
            desc = "User Defined Function with event type 0, 1, and 2 as arguments";
        } Udf[51:44] = 0x0;
        field {
            sw = rw;
            hw = r;
            desc = "Select an Action";
        } Action2[57:52] = 0x0;
        field {
            sw = rw;
            hw = r;
            desc = "Select an Action";
        } Action3[63:58] = 0x0;
    } CDbgNode2Eap2 @ 0x2268;
    reg {
        desc = "CLA Action(s) are tied to events(s) using \\\"event-action pairing\\\" registers. One of he 8 EAPs (4 EAPs per Node).";
        regwidth = 0x40;

        field {
            sw = rw;
            hw = r;
            desc = "Select Destination Node";
        } DestNode[1:0] = 0x0;
        field {
            sw = rw;
            hw = r;
            desc = "Select an Action";
        } Action0[7:2] = 0x0;
        field {
            sw = rw;
            hw = r;
            desc = "Select an Action";
        } Action1[13:8] = 0x0;
        field {
            sw = rw;
            hw = r;
            desc = "Relation to be satisfied among events to activate the actions";
        } LogicalOp[15:14] = 0x0;
        field {
            sw = rw;
            hw = r;
            desc = "Select a trigger event";
        } EventType0[21:16] = 0x0;
        field {
            sw = rw;
            hw = r;
            desc = "Select a trigger event";
        } EventType1[27:22] = 0x0;
        field {
            sw = rw;
            hw = r;
            desc = "Select the bit position of custom action bus to be set when EAP trigger is met. External blocks can define and implement the specific action for a given bit.";
        } CustomAction0[31:28] = 0x0;
        field {
            sw = rw;
            hw = r;
            desc = "Select the bit position of custom action bus to be set when EAP trigger is met. External blocks can define and implement the specific action for a given bit.";
        } CustomAction1[35:32] = 0x0;
        field {
            sw = rw;
            hw = r;
            desc = "custom_action0 is valid only if custom_action0_enable is set";
        } CustomAction0Enable[36:36] = 0x0;
        field {
            sw = rw;
            hw = r;
            desc = "custom_action1 is valid only if custom_action1_enable is set";
        } CustomAction1Enable[37:37] = 0x0;
        field {
            sw = rw;
            hw = r;
            desc = "Select a trigger event";
        } EventType2[43:38] = 0x0;
        field {
            sw = rw;
            hw = r;
            desc = "User Defined Function with event type 0, 1, and 2 as arguments";
        } Udf[51:44] = 0x0;
        field {
            sw = rw;
            hw = r;
            desc = "Select an Action";
        } Action2[57:52] = 0x0;
        field {
            sw = rw;
            hw = r;
            desc = "Select an Action";
        } Action3[63:58] = 0x0;
    } CDbgNode2Eap3 @ 0x2270;
    reg {
        desc = "CLA Action(s) are tied to events(s) using \\\"event-action pairing\\\" registers. One of he 8 EAPs (4 EAPs per Node).";
        regwidth = 0x40;

        field {
            sw = rw;
            hw = r;
            desc = "Select Destination Node";
        } DestNode[1:0] = 0x0;
        field {
            sw = rw;
            hw = r;
            desc = "Select an Action";
        } Action0[7:2] = 0x0;
        field {
            sw = rw;
            hw = r;
            desc = "Select an Action";
        } Action1[13:8] = 0x0;
        field {
            sw = rw;
            hw = r;
            desc = "Relation to be satisfied among events to activate the actions";
        } LogicalOp[15:14] = 0x0;
        field {
            sw = rw;
            hw = r;
            desc = "Select a trigger event";
        } EventType0[21:16] = 0x0;
        field {
            sw = rw;
            hw = r;
            desc = "Select a trigger event";
        } EventType1[27:22] = 0x0;
        field {
            sw = rw;
            hw = r;
            desc = "Select the bit position of custom action bus to be set when EAP trigger is met. External blocks can define and implement the specific action for a given bit.";
        } CustomAction0[31:28] = 0x0;
        field {
            sw = rw;
            hw = r;
            desc = "Select the bit position of custom action bus to be set when EAP trigger is met. External blocks can define and implement the specific action for a given bit.";
        } CustomAction1[35:32] = 0x0;
        field {
            sw = rw;
            hw = r;
            desc = "custom_action0 is valid only if custom_action0_enable is set";
        } CustomAction0Enable[36:36] = 0x0;
        field {
            sw = rw;
            hw = r;
            desc = "custom_action1 is valid only if custom_action1_enable is set";
        } CustomAction1Enable[37:37] = 0x0;
        field {
            sw = rw;
            hw = r;
            desc = "Select a trigger event";
        } EventType2[43:38] = 0x0;
        field {
            sw = rw;
            hw = r;
            desc = "User Defined Function with event type 0, 1, and 2 as arguments";
        } Udf[51:44] = 0x0;
        field {
            sw = rw;
            hw = r;
            desc = "Select an Action";
        } Action2[57:52] = 0x0;
        field {
            sw = rw;
            hw = r;
            desc = "Select an Action";
        } Action3[63:58] = 0x0;
    } CDbgNode3Eap2 @ 0x2278;
    reg {
        desc = "CLA Action(s) are tied to events(s) using \\\"event-action pairing\\\" registers. One of he 8 EAPs (4 EAPs per Node).";
        regwidth = 0x40;

        field {
            sw = rw;
            hw = r;
            desc = "Select Destination Node";
        } DestNode[1:0] = 0x0;
        field {
            sw = rw;
            hw = r;
            desc = "Select an Action";
        } Action0[7:2] = 0x0;
        field {
            sw = rw;
            hw = r;
            desc = "Select an Action";
        } Action1[13:8] = 0x0;
        field {
            sw = rw;
            hw = r;
            desc = "Relation to be satisfied among events to activate the actions";
        } LogicalOp[15:14] = 0x0;
        field {
            sw = rw;
            hw = r;
            desc = "Select a trigger event";
        } EventType0[21:16] = 0x0;
        field {
            sw = rw;
            hw = r;
            desc = "Select a trigger event";
        } EventType1[27:22] = 0x0;
        field {
            sw = rw;
            hw = r;
            desc = "Select the bit position of custom action bus to be set when EAP trigger is met. External blocks can define and implement the specific action for a given bit.";
        } CustomAction0[31:28] = 0x0;
        field {
            sw = rw;
            hw = r;
            desc = "Select the bit position of custom action bus to be set when EAP trigger is met. External blocks can define and implement the specific action for a given bit.";
        } CustomAction1[35:32] = 0x0;
        field {
            sw = rw;
            hw = r;
            desc = "custom_action0 is valid only if custom_action0_enable is set";
        } CustomAction0Enable[36:36] = 0x0;
        field {
            sw = rw;
            hw = r;
            desc = "custom_action1 is valid only if custom_action1_enable is set";
        } CustomAction1Enable[37:37] = 0x0;
        field {
            sw = rw;
            hw = r;
            desc = "Select a trigger event";
        } EventType2[43:38] = 0x0;
        field {
            sw = rw;
            hw = r;
            desc = "User Defined Function with event type 0, 1, and 2 as arguments";
        } Udf[51:44] = 0x0;
        field {
            sw = rw;
            hw = r;
            desc = "Select an Action";
        } Action2[57:52] = 0x0;
        field {
            sw = rw;
            hw = r;
            desc = "Select an Action";
        } Action3[63:58] = 0x0;
    } CDbgNode3Eap3 @ 0x2280;
    reg {
        regwidth = 0x40;

        field {
            sw = r;
            hw = w;
        } Value[63:0] = 0x0;
    } CDbgSignalSnapshotNode0Eap2Lo @ 0x2288;
    reg {
        regwidth = 0x40;

        field {
            sw = r;
            hw = w;
        } Value[63:0] = 0x0;
    } CDbgSignalSnapshotNode0Eap3Lo @ 0x2290;
    reg {
        regwidth = 0x40;

        field {
            sw = r;
            hw = w;
        } Value[63:0] = 0x0;
    } CDbgSignalSnapshotNode1Eap2Lo @ 0x2298;
    reg {
        regwidth = 0x40;

        field {
            sw = r;
            hw = w;
        } Value[63:0] = 0x0;
    } CDbgSignalSnapshotNode1Eap3Lo @ 0x22A0;
    reg {
        regwidth = 0x40;

        field {
            sw = r;
            hw = w;
        } Value[63:0] = 0x0;
    } CDbgSignalSnapshotNode2Eap2Lo @ 0x22A8;
    reg {
        regwidth = 0x40;

        field {
            sw = r;
            hw = w;
        } Value[63:0] = 0x0;
    } CDbgSignalSnapshotNode2Eap3Lo @ 0x22B0;
    reg {
        regwidth = 0x40;

        field {
            sw = r;
            hw = w;
        } Value[63:0] = 0x0;
    } CDbgSignalSnapshotNode3Eap2Lo @ 0x22B8;
    reg {
        regwidth = 0x40;

        field {
            sw = r;
            hw = w;
        } Value[63:0] = 0x0;
    } CDbgSignalSnapshotNode3Eap3Lo @ 0x22C0;
    reg {
        regwidth = 0x40;

        field {
            sw = rw;
            hw = r;
            desc = "Dbg Mux Shifted signals Select Bits for Lane 0";
        } Muxselseg0[1:0] = 0x0;
        field {
            sw = rw;
            hw = r;
            desc = "Dbg Mux Shifted signals Select Bits for Lane 1";
        } Muxselseg1[3:2] = 0x0;
        field {
            sw = rw;
            hw = r;
            desc = "Dbg Mux Shifted signals Select Bits for Lane 2";
        } Muxselseg2[5:4] = 0x0;
        field {
            sw = rw;
            hw = r;
            desc = "Dbg Mux Shifted signals Select Bits for Lane 3";
        } Muxselseg3[7:6] = 0x0;
        field {
            sw = rw;
            hw = r;
            desc = "Dbg Mux Shifted signals Select Bits for Lane 4";
        } Muxselseg4[9:8] = 0x0;
        field {
            sw = rw;
            hw = r;
            desc = "Dbg Mux Shifted signals Select Bits for Lane 5";
        } Muxselseg5[11:10] = 0x0;
        field {
            sw = rw;
            hw = r;
            desc = "Dbg Mux Shifted signals Select Bits for Lane 6";
        } Muxselseg6[13:12] = 0x0;
        field {
            sw = rw;
            hw = r;
            desc = "Dbg Mux Shifted signals Select Bits for Lane 7";
        } Muxselseg7[15:14] = 0x0;
        field {
            sw = rw;
            hw = r;
        } Muxselseg8[17:16] = 0x0;
        field {
            sw = rw;
            hw = r;
        } Muxselseg9[19:18] = 0x0;
        field {
            sw = rw;
            hw = r;
        } Muxselseg10[21:20] = 0x0;
        field {
            sw = rw;
            hw = r;
        } Muxselseg11[23:22] = 0x0;
        field {
            sw = rw;
            hw = r;
        } Muxselseg12[25:24] = 0x0;
        field {
            sw = rw;
            hw = r;
        } Muxselseg13[27:26] = 0x0;
        field {
            sw = rw;
            hw = r;
        } Muxselseg14[29:28] = 0x0;
        field {
            sw = rw;
            hw = r;
        } Muxselseg15[31:30] = 0x0;
        field {
            sw = rw;
            hw = r;
        } Rsvd[63:32] = 0x0;
    } CDbgSignalDelayMuxSel @ 0x22C8;
    reg {
        desc = "This value determines the time stretched pulse duration for the cross trigger. 8 bits for each of the two triggers.";
        regwidth = 0x40;

        field {
            sw = rw;
            hw = r;
        } Xtrigger0Stretch[7:0] = 0x0;
        field {
            sw = rw;
            hw = r;
        } Xtrigger1Stretch[15:8] = 0x0;
        field {
            sw = rw;
            hw = r;
        } Rsvd[63:16] = 0x0;
    } CDbgClaXtriggerTimestretch @ 0x22D8;
    reg {
        regwidth = 0x40;

        field {
            sw = r;
            hw = w;
        } Timestamp[63:0] = 0x0;
    } CDbgClaTimestamp @ 0x22F0;
    reg {
        desc = "This value is loaded to the finegrain timestamp counter based on a cross trigger to sync the time value across the multiple cluster's CLA blocks";
        regwidth = 0x40;

        field {
            sw = rw;
            hw = r;
        } TimestampSync[63:0] = 0x0;
    } CDbgClaTimestampSync @ 0x22F8;
    reg {
        regwidth = 0x40;

        field {
            sw = rw;
            hw = rw;
        } TsCapture[0:0] = 0x0;
        field {
            sw = rw;
            hw = r;
        } DebugMarker[8:1] = 0x0;
        field {
            sw = rw;
            hw = rw;
        } TsSyncOffset[9:9] = 0x0;
        field {
            sw = rw;
            hw = rw;
        } TsSyncRaw[10:10] = 0x0;
        field {
            sw = rw;
            hw = r;
        } Rsvd1[63:11] = 0x0;
    } CDbgClaTimestampConfig @ 0x2300;
    reg {
        desc = "Scratchpad register for DV";
        regwidth = 0x40;

        field {
            sw = rw;
            hw = r;
        } Data[63:0] = 0xBFBFBFBFBFBFBFBF;
    } CrScratchpad @ 0x23F0;
    reg {
        regwidth = 0x40;

        field {
            sw = rw;
            hw = r;
        } Value[63:0] = 0x0;
    } CDbgSignalMask0Hi @ 0x2400;
    reg {
        regwidth = 0x40;

        field {
            sw = rw;
            hw = r;
        } Value[63:0] = 0x0;
    } CDbgSignalMatch0Hi @ 0x2408;
    reg {
        regwidth = 0x40;

        field {
            sw = rw;
            hw = r;
        } Value[63:0] = 0x0;
    } CDbgSignalMask1Hi @ 0x2410;
    reg {
        regwidth = 0x40;

        field {
            sw = rw;
            hw = r;
        } Value[63:0] = 0x0;
    } CDbgSignalMatch1Hi @ 0x2418;
    reg {
        regwidth = 0x40;

        field {
            sw = rw;
            hw = r;
        } Value[63:0] = 0x0;
    } CDbgSignalMask2Hi @ 0x2420;
    reg {
        regwidth = 0x40;

        field {
            sw = rw;
            hw = r;
        } Value[63:0] = 0x0;
    } CDbgSignalMatch2Hi @ 0x2428;
    reg {
        regwidth = 0x40;

        field {
            sw = rw;
            hw = r;
        } Value[63:0] = 0x0;
    } CDbgSignalMask3Hi @ 0x2430;
    reg {
        regwidth = 0x40;

        field {
            sw = rw;
            hw = r;
        } Value[63:0] = 0x0;
    } CDbgSignalMatch3Hi @ 0x2438;
    reg {
        regwidth = 0x40;

        field {
            sw = rw;
            hw = r;
        } Dbmmode[1:0] = 0x0;
        field {
            sw = rw;
            hw = r;
        } Dbmid[7:2] = 0x0;
        field {
            sw = rw;
            hw = r;
        } Rsvd158[15:8] = 0x0;
        field {
            sw = rw;
            hw = r;
        } Muxselseg8[21:16] = 0x0;
        field {
            sw = rw;
            hw = r;
        } Muxselseg9[27:22] = 0x0;
        field {
            sw = rw;
            hw = r;
        } Muxselseg10[33:28] = 0x0;
        field {
            sw = rw;
            hw = r;
        } Muxselseg11[39:34] = 0x0;
        field {
            sw = rw;
            hw = r;
        } Muxselseg12[45:40] = 0x0;
        field {
            sw = rw;
            hw = r;
        } Muxselseg13[51:46] = 0x0;
        field {
            sw = rw;
            hw = r;
        } Muxselseg14[57:52] = 0x0;
        field {
            sw = rw;
            hw = r;
        } Muxselseg15[63:58] = 0x0;
    } CDbgMuxSelHi @ 0x2440;
    reg {
        regwidth = 0x40;

        field {
            sw = rw;
            hw = r;
        } Value[63:0] = 0x0;
    } CDbgTransitionMaskHi @ 0x2448;
    reg {
        regwidth = 0x40;

        field {
            sw = rw;
            hw = r;
        } Value[63:0] = 0x0;
    } CDbgTransitionFromValueHi @ 0x2450;
    reg {
        regwidth = 0x40;

        field {
            sw = rw;
            hw = r;
        } Value[63:0] = 0x0;
    } CDbgTransitionToValueHi @ 0x2458;
    reg {
        regwidth = 0x40;

        field {
            sw = rw;
            hw = r;
        } Value[63:0] = 0x0;
    } CDbgOnesCountMaskHi @ 0x2460;
    reg {
        regwidth = 0x40;

        field {
            sw = rw;
            hw = r;
        } Mask[63:0] = 0x0;
    } CDbgAnyChangeHi @ 0x2468;
    reg {
        regwidth = 0x40;

        field {
            sw = r;
            hw = w;
        } Value[63:0] = 0x0;
    } CDbgSignalSnapshotNode0Eap0Hi @ 0x2470;
    reg {
        regwidth = 0x40;

        field {
            sw = r;
            hw = w;
        } Value[63:0] = 0x0;
    } CDbgSignalSnapshotNode0Eap1Hi @ 0x2478;
    reg {
        regwidth = 0x40;

        field {
            sw = r;
            hw = w;
        } Value[63:0] = 0x0;
    } CDbgSignalSnapshotNode1Eap0Hi @ 0x2480;
    reg {
        regwidth = 0x40;

        field {
            sw = r;
            hw = w;
        } Value[63:0] = 0x0;
    } CDbgSignalSnapshotNode1Eap1Hi @ 0x2488;
    reg {
        regwidth = 0x40;

        field {
            sw = r;
            hw = w;
        } Value[63:0] = 0x0;
    } CDbgSignalSnapshotNode2Eap0Hi @ 0x2490;
    reg {
        regwidth = 0x40;

        field {
            sw = r;
            hw = w;
        } Value[63:0] = 0x0;
    } CDbgSignalSnapshotNode2Eap1Hi @ 0x2498;
    reg {
        regwidth = 0x40;

        field {
            sw = r;
            hw = w;
        } Value[63:0] = 0x0;
    } CDbgSignalSnapshotNode3Eap0Hi @ 0x24A0;
    reg {
        regwidth = 0x40;

        field {
            sw = r;
            hw = w;
        } Value[63:0] = 0x0;
    } CDbgSignalSnapshotNode3Eap1Hi @ 0x24A8;
    reg {
        regwidth = 0x40;

        field {
            sw = r;
            hw = w;
        } Value[63:0] = 0x0;
    } CDbgSignalSnapshotNode0Eap2Hi @ 0x24B0;
    reg {
        regwidth = 0x40;

        field {
            sw = r;
            hw = w;
        } Value[63:0] = 0x0;
    } CDbgSignalSnapshotNode0Eap3Hi @ 0x24B8;
    reg {
        regwidth = 0x40;

        field {
            sw = r;
            hw = w;
        } Value[63:0] = 0x0;
    } CDbgSignalSnapshotNode1Eap2Hi @ 0x24C0;
    reg {
        regwidth = 0x40;

        field {
            sw = r;
            hw = w;
        } Value[63:0] = 0x0;
    } CDbgSignalSnapshotNode1Eap3Hi @ 0x24C8;
    reg {
        regwidth = 0x40;

        field {
            sw = r;
            hw = w;
        } Value[63:0] = 0x0;
    } CDbgSignalSnapshotNode2Eap2Hi @ 0x24D0;
    reg {
        regwidth = 0x40;

        field {
            sw = r;
            hw = w;
        } Value[63:0] = 0x0;
    } CDbgSignalSnapshotNode2Eap3Hi @ 0x24D8;
    reg {
        regwidth = 0x40;

        field {
            sw = r;
            hw = w;
        } Value[63:0] = 0x0;
    } CDbgSignalSnapshotNode3Eap2Hi @ 0x24E0;
    reg {
        regwidth = 0x40;

        field {
            sw = r;
            hw = w;
        } Value[63:0] = 0x0;
    } CDbgSignalSnapshotNode3Eap3Hi @ 0x24E8;
    reg {
        regwidth = 0x40;

        field {
            sw = rw;
            hw = r;
        } LfsrActive[0:0] = 0x0;
        field {
            sw = rw;
            hw = rw;
        } Lfsr[63:1] = 0x0;
    } CDbgLfsr @ 0x24F0;
    reg {
        regwidth = 0x40;

        field {
            sw = rw;
            hw = r;
        } Rsvd0[0:0] = 0x0;
        field {
            sw = rw;
            hw = r;
        } Mask[63:1] = 0x0;
    } CDbgLfsrMask @ 0x24F8;
    reg {
        regwidth = 0x40;

        field {
            sw = r;
            hw = w;
        } Timestamp[63:0] = 0x0;
    } CDbgTimestampCapture @ 0x2500;
    reg {
        regwidth = 0x40;

        field {
            sw = rw;
            hw = r;
        } Value[63:0] = 0x0;
    } CDbgCompare0Lo @ 0x2508;
    reg {
        regwidth = 0x40;

        field {
            sw = rw;
            hw = r;
        } Value[63:0] = 0x0;
    } CDbgCompare0MaskLo @ 0x2510;
    reg {
        regwidth = 0x40;

        field {
            sw = rw;
            hw = r;
        } Value[63:0] = 0x0;
    } CDbgCompare1Lo @ 0x2518;
    reg {
        regwidth = 0x40;

        field {
            sw = rw;
            hw = r;
        } Value[63:0] = 0x0;
    } CDbgCompare1MaskLo @ 0x2520;
    reg {
        regwidth = 0x40;

        field {
            sw = rw;
            hw = r;
        } Value[63:0] = 0x0;
    } CDbgCompare2Lo @ 0x2528;
    reg {
        regwidth = 0x40;

        field {
            sw = rw;
            hw = r;
        } Value[63:0] = 0x0;
    } CDbgCompare2MaskLo @ 0x2530;
    reg {
        regwidth = 0x40;

        field {
            sw = rw;
            hw = r;
        } Value[63:0] = 0x0;
    } CDbgCompare3Lo @ 0x2538;
    reg {
        regwidth = 0x40;

        field {
            sw = rw;
            hw = r;
        } Value[63:0] = 0x0;
    } CDbgCompare3MaskLo @ 0x2540;
    reg {
        regwidth = 0x40;

        field {
            sw = rw;
            hw = r;
        } Value[63:0] = 0x0;
    } CDbgCompare0Hi @ 0x2548;
    reg {
        regwidth = 0x40;

        field {
            sw = rw;
            hw = r;
        } Value[63:0] = 0x0;
    } CDbgCompare0MaskHi @ 0x2550;
    reg {
        regwidth = 0x40;

        field {
            sw = rw;
            hw = r;
        } Value[63:0] = 0x0;
    } CDbgCompare1Hi @ 0x2558;
    reg {
        regwidth = 0x40;

        field {
            sw = rw;
            hw = r;
        } Value[63:0] = 0x0;
    } CDbgCompare1MaskHi @ 0x2560;
    reg {
        regwidth = 0x40;

        field {
            sw = rw;
            hw = r;
        } Value[63:0] = 0x0;
    } CDbgCompare2Hi @ 0x2568;
    reg {
        regwidth = 0x40;

        field {
            sw = rw;
            hw = r;
        } Value[63:0] = 0x0;
    } CDbgCompare2MaskHi @ 0x2570;
    reg {
        regwidth = 0x40;

        field {
            sw = rw;
            hw = r;
        } Value[63:0] = 0x0;
    } CDbgCompare3Hi @ 0x2578;
    reg {
        regwidth = 0x40;

        field {
            sw = rw;
            hw = r;
        } Value[63:0] = 0x0;
    } CDbgCompare3MaskHi @ 0x2580;
    reg {
        desc = "Additional scratch register for DV and potential ECO usage";
        regwidth = 0x40;

        field {
            sw = rw;
            hw = r;
        } Data[63:0] = 0x0;
    } Scratch @ 0x2FF8;

    // ---------------------------------------------------------------------
    // DST trace-source MMRs (mmrs.sv block 3, DST_START_IDX)
    // ---------------------------------------------------------------------
    reg {
        regwidth = 0x20;

        field {
            sw = rw;
            hw = r;
        } Trdstactive[0:0] = 0x0;
        field {
            sw = rw;
            hw = r;
        } Trdstenable[1:1] = 0x0;
        field {
            sw = rw;
            hw = rw;
        } Trdstinsttracing[2:2] = 0x0;
        field {
            sw = r;
            hw = w;
        } Trdstempty[3:3] = 0x1;
        field {
            sw = r;
            hw = r;
        } Trdstinstmode[6:4] = 0x6;
        field {
            sw = r;
            hw = r;
        } Trdstcontext[9:9] = 0x0;
        field {
            sw = rw;
            hw = r;
        } Trdstinsttriggerenable[11:11] = 0x0;
        field {
            sw = r;
            hw = r;
        } Trdstinststalloroverflow[12:12] = 0x0;
        field {
            sw = r;
            hw = r;
        } Trdstinststallena[13:13] = 0x0;
        field {
            sw = r;
            hw = r;
        } Trdstinhibitsrc[15:15] = 0x0;
        field {
            sw = rw;
            hw = r;
            desc = "When the field is set tp 2'b10, sent timestamp. All other values not NA.";
        } Trdstsyncmode[17:16] = 0x0;
        field {
            sw = rw;
            hw = r;
            desc = "When trDstSyncMode is set to 2'b10, timestamp will be sent for every 2^(trDstSyncMax + 4) Cluster clocks.";
        } Trdstsyncmax[23:20] = 0x0;
        field {
            sw = rw;
            hw = r;
            desc = "bit[0]: XOR Enable, bit[1]: VLT Enable. Supported values : 2'b3 (XOR+VLT Compression), 2'b1 (XOR Compression), 2'b0 (No Compression)";
        } Trdstformat[26:24] = 0x3;
    } Trdstcontrol @ 0x3000;
    reg {
        regwidth = 0x20;

        field {
            sw = r;
            hw = r;
        } Trdstvermajor[3:0] = 0x1;
        field {
            sw = r;
            hw = r;
        } Trdstverminor[7:4] = 0x0;
        field {
            sw = r;
            hw = r;
        } Trdstcomptype[11:8] = 0x1;
        field {
            sw = r;
            hw = r;
        } Trdstprotocolmajor[19:16] = 0x1;
        field {
            sw = r;
            hw = r;
        } Trdstprotocolminor[23:20] = 0x0;
        field {
            sw = rw;
            hw = r;
            desc = "Specify frame length. Frame Length = trDstVendorFrameLength* 64 ; Frame Length should be a multiple of Bank Data Width.";
        } Trdstvendorframelength[27:24] = 0x1;
        field {
            sw = rw;
            hw = r;
            desc = "Specify Stream length. A stream starts with \\\"no compressed packet\\\". Stream length specifies number of frames before a non-compressed packet is sent.Stream Length = 32* 2^(trDstVendorStreamLength + 1)";
        } Trdstvendorstreamlength[30:28] = 0x4;
        field {
            sw = rw;
            hw = r;
        } Trdsttimestampconfig[31:31] = 0x0;
    } Trdstimpl @ 0x3004;
    reg {
        regwidth = 0x20;

        field {
            sw = r;
            hw = r;
        } Trdstinstnoaddrdiff[0:0] = 0x0;
        field {
            sw = r;
            hw = r;
        } Trdstinstnotrapaddr[1:1] = 0x0;
        field {
            sw = r;
            hw = r;
        } Trdstinstenrepeatedhistory[8:8] = 0x0;
        field {
            sw = rw;
            hw = r;
        } Trdstsrcid[27:16] = 0x0;
        field {
            sw = rw;
            hw = r;
        } Trdstsrcbits[31:28] = 0x4;
    } Trdstinstfeatures @ 0x3008;
    reg {
        regwidth = 0x20;

        field {
            sw = rw;
            hw = r;
            desc = "Trace Source ID (FIXME: Base Address, Tool Issue)";
        } TraceSourceId[3:0] = 0x0;
        field {
            sw = rw;
            hw = r;
            desc = "Use \\\"Filler Packet\\\" to align a stream of trace packets within a frame boundary.";
        } TraceFrameFillByte[11:4] = 0x81;
        field {
            sw = rw;
            hw = r;
            desc = "Use trDstImpl[trDstVendorFrameLength] for Frame Length programming. Register field ZBB-ed.";
        } FrameLenghtInBytes[15:12] = 0x2;
        field {
            sw = rw;
            hw = r;
            desc = "Enable Frame Mode (Frame Mode: Always pack \\\"frame length\\\" number of bytes for trace transmission). If flush to memory is stalled (due to silicon bug), we can have incomplete packets in memory. Frame Mode will help SW decoder to avoid reading incomplete transmitted packets. In Frame Mode, SW will get a memory pointer that is aligned to Frame Length. HW will ensure  there are no incomplete packets incluced in the region pointed by memory pointer.";
        } FrameModeEnable[20:20] = 0x1;
        field {
            sw = rw;
            hw = r;
            desc = "Closure Mode: 1: Close frame with a packet no larger than max packet size  before any overflow (due to packets crossing frame boundary). 0: Close frame when packets cross boundary. Push back packet crossing frame boundary to packet generator.";
        } FrameClosureMode[21:21] = 0x0;
    } CDbgDebugTraceCfg @ 0x31A0;
    reg {
        regwidth = 0x20;

        field {
            sw = rw;
            hw = r;
        } Data[31:0] = 0x0;
    } TrDstScratchLo @ 0x3FF8;
    reg {
        regwidth = 0x20;

        field {
            sw = rw;
            hw = r;
        } Data[31:0] = 0x0;
    } TrDstScratchHi @ 0x3FFC;
};

/*
        AUTOGENERATED ADDRESS MAP -- see the header for the generating parameters


        // DST trace-sink MMRs   (mmrs.sv block 0, DST_SINK_BLK_IDX)
        Trdstramcontrol                    @ 0x0000
        Trdstramimpl                       @ 0x0004
        Trdstramstartlow                   @ 0x0010
        Trdstramstarthigh                  @ 0x0014
        Trdstramlimitlow                   @ 0x0018
        Trdstramlimithigh                  @ 0x001C
        Trdstramwplow                      @ 0x0020
        Trdstramwphigh                     @ 0x0024
        Trdstramrplow                      @ 0x0028
        Trdstramrphigh                     @ 0x002C
        Trdstramdata                       @ 0x0040
        TrDstSinkScratchLo                 @ 0x0FF8
        TrDstSinkScratchHi                 @ 0x0FFC

        // Trace-funnel MMRs     (mmrs.sv block 1, FUNNEL_BLK_IDX)
        Trfunnelcontrol                    @ 0x1000
        Trfunnelimpl                       @ 0x1004
        Trfunneldisinput                   @ 0x1008
        TrFunnelScratchLo                  @ 0x1FF8
        TrFunnelScratchHi                  @ 0x1FFC

        // Core Logic Analyzer   (mmrs.sv block 2, CLA_START_IDX)
        CDbgClaCounter0Cfg                 @ 0x2100
        CDbgClaCounter1Cfg                 @ 0x2108
        CDbgClaCounter2Cfg                 @ 0x2110
        CDbgClaCounter3Cfg                 @ 0x2118
        CDbgNode0Eap0                      @ 0x2120
        CDbgNode0Eap1                      @ 0x2128
        CDbgNode1Eap0                      @ 0x2130
        CDbgNode1Eap1                      @ 0x2138
        CDbgNode2Eap0                      @ 0x2140
        CDbgNode2Eap1                      @ 0x2148
        CDbgNode3Eap0                      @ 0x2150
        CDbgNode3Eap1                      @ 0x2158
        CDbgSignalMask0Lo                  @ 0x2160
        CDbgSignalMatch0Lo                 @ 0x2168
        CDbgSignalMask1Lo                  @ 0x2170
        CDbgSignalMatch1Lo                 @ 0x2178
        CDbgSignalEdgeDetectCfg            @ 0x2180
        CDbgEapStatus                      @ 0x2188
        CDbgClaCtrlStatus                  @ 0x2190
        CDbgMuxSelLo                       @ 0x2198
        CDbgRsvd1                          @ 0x21A0
        CDbgRsvd2                          @ 0x21A8
        CDbgTransitionMaskLo               @ 0x21B0
        CDbgTransitionFromValueLo          @ 0x21B8
        CDbgTransitionToValueLo            @ 0x21C0
        CDbgOnesCountMaskLo                @ 0x21C8
        CDbgOnesCountValue                 @ 0x21D0
        CDbgAnyChangeLo                    @ 0x21D8
        CDbgSignalSnapshotNode0Eap0Lo      @ 0x21E0
        CDbgSignalSnapshotNode0Eap1Lo      @ 0x21E8
        CDbgSignalSnapshotNode1Eap0Lo      @ 0x21F0
        CDbgSignalSnapshotNode1Eap1Lo      @ 0x21F8
        CDbgSignalSnapshotNode2Eap0Lo      @ 0x2200
        CDbgSignalSnapshotNode2Eap1Lo      @ 0x2208
        CDbgSignalSnapshotNode3Eap0Lo      @ 0x2210
        CDbgSignalSnapshotNode3Eap1Lo      @ 0x2218
        CDbgClaTimeMatch                   @ 0x2220
        CDbgSignalMask2Lo                  @ 0x2228
        CDbgSignalMatch2Lo                 @ 0x2230
        CDbgSignalMask3Lo                  @ 0x2238
        CDbgSignalMatch3Lo                 @ 0x2240
        CDbgNode0Eap2                      @ 0x2248
        CDbgNode0Eap3                      @ 0x2250
        CDbgNode1Eap2                      @ 0x2258
        CDbgNode1Eap3                      @ 0x2260
        CDbgNode2Eap2                      @ 0x2268
        CDbgNode2Eap3                      @ 0x2270
        CDbgNode3Eap2                      @ 0x2278
        CDbgNode3Eap3                      @ 0x2280
        CDbgSignalSnapshotNode0Eap2Lo      @ 0x2288
        CDbgSignalSnapshotNode0Eap3Lo      @ 0x2290
        CDbgSignalSnapshotNode1Eap2Lo      @ 0x2298
        CDbgSignalSnapshotNode1Eap3Lo      @ 0x22A0
        CDbgSignalSnapshotNode2Eap2Lo      @ 0x22A8
        CDbgSignalSnapshotNode2Eap3Lo      @ 0x22B0
        CDbgSignalSnapshotNode3Eap2Lo      @ 0x22B8
        CDbgSignalSnapshotNode3Eap3Lo      @ 0x22C0
        CDbgSignalDelayMuxSel              @ 0x22C8
        CDbgClaXtriggerTimestretch         @ 0x22D8
        CDbgClaTimestamp                   @ 0x22F0
        CDbgClaTimestampSync               @ 0x22F8
        CDbgClaTimestampConfig             @ 0x2300
        CrScratchpad                       @ 0x23F0
        CDbgSignalMask0Hi                  @ 0x2400
        CDbgSignalMatch0Hi                 @ 0x2408
        CDbgSignalMask1Hi                  @ 0x2410
        CDbgSignalMatch1Hi                 @ 0x2418
        CDbgSignalMask2Hi                  @ 0x2420
        CDbgSignalMatch2Hi                 @ 0x2428
        CDbgSignalMask3Hi                  @ 0x2430
        CDbgSignalMatch3Hi                 @ 0x2438
        CDbgMuxSelHi                       @ 0x2440
        CDbgTransitionMaskHi               @ 0x2448
        CDbgTransitionFromValueHi          @ 0x2450
        CDbgTransitionToValueHi            @ 0x2458
        CDbgOnesCountMaskHi                @ 0x2460
        CDbgAnyChangeHi                    @ 0x2468
        CDbgSignalSnapshotNode0Eap0Hi      @ 0x2470
        CDbgSignalSnapshotNode0Eap1Hi      @ 0x2478
        CDbgSignalSnapshotNode1Eap0Hi      @ 0x2480
        CDbgSignalSnapshotNode1Eap1Hi      @ 0x2488
        CDbgSignalSnapshotNode2Eap0Hi      @ 0x2490
        CDbgSignalSnapshotNode2Eap1Hi      @ 0x2498
        CDbgSignalSnapshotNode3Eap0Hi      @ 0x24A0
        CDbgSignalSnapshotNode3Eap1Hi      @ 0x24A8
        CDbgSignalSnapshotNode0Eap2Hi      @ 0x24B0
        CDbgSignalSnapshotNode0Eap3Hi      @ 0x24B8
        CDbgSignalSnapshotNode1Eap2Hi      @ 0x24C0
        CDbgSignalSnapshotNode1Eap3Hi      @ 0x24C8
        CDbgSignalSnapshotNode2Eap2Hi      @ 0x24D0
        CDbgSignalSnapshotNode2Eap3Hi      @ 0x24D8
        CDbgSignalSnapshotNode3Eap2Hi      @ 0x24E0
        CDbgSignalSnapshotNode3Eap3Hi      @ 0x24E8
        CDbgLfsr                           @ 0x24F0
        CDbgLfsrMask                       @ 0x24F8
        CDbgTimestampCapture               @ 0x2500
        CDbgCompare0Lo                     @ 0x2508
        CDbgCompare0MaskLo                 @ 0x2510
        CDbgCompare1Lo                     @ 0x2518
        CDbgCompare1MaskLo                 @ 0x2520
        CDbgCompare2Lo                     @ 0x2528
        CDbgCompare2MaskLo                 @ 0x2530
        CDbgCompare3Lo                     @ 0x2538
        CDbgCompare3MaskLo                 @ 0x2540
        CDbgCompare0Hi                     @ 0x2548
        CDbgCompare0MaskHi                 @ 0x2550
        CDbgCompare1Hi                     @ 0x2558
        CDbgCompare1MaskHi                 @ 0x2560
        CDbgCompare2Hi                     @ 0x2568
        CDbgCompare2MaskHi                 @ 0x2570
        CDbgCompare3Hi                     @ 0x2578
        CDbgCompare3MaskHi                 @ 0x2580
        Scratch                            @ 0x2FF8

        // DST trace-source MMRs (mmrs.sv block 3, DST_START_IDX)
        Trdstcontrol                       @ 0x3000
        Trdstimpl                          @ 0x3004
        Trdstinstfeatures                  @ 0x3008
        CDbgDebugTraceCfg                  @ 0x31A0
        TrDstScratchLo                     @ 0x3FF8
        TrDstScratchHi                     @ 0x3FFC
*/
