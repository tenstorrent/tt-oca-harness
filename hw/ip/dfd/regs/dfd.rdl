addrmap smc_cla {

        reg {
        desc = "";
        regwidth = 0x40;

        field {
            desc = "Mode selection, 0: DBM off, 1: Normal debug mode, 2: DBM ID output mode, 3: Toggle Mode";
            sw = rw;
            hw = r;

        } Dbmmode[1:0] = 0x0;
        field {
            desc = "Unique DBM ID of the DBM instance";
            sw = rw;
            hw = r;

        } Dbmid[7:2] = 0x0;
        field {
            sw = rw;
            hw = r;

        } Rsvd158[15:8] = 0x0;
        field {
            desc = "Mux Select Bits for Lane 0. Split debug bus into 16 bit segments. Seg0 = debug bus [15:0], Seg1 = debug bus[31:16],.... If all bits are 0, Lane0 = Seg0, if bit[0] = 1, Lane0 = Seg4, if bit[1] =1, Lane0 = Seg5,...";
            sw = rw;
            hw = r;

        } Muxselseg0[21:16] = 0x0;
        field {
            desc = "Mux Select Bits for Lane 1. Split debug bus into 16 bit segments. Seg0 = debug bus [15:0], Seg1 = debug bus[31:16],.... If all bits are 0, Lane1= Seg1, if bit[0] = 1, Lane1 = Seg4, if bit[1] =1, Lane1 = Seg5,...";
            sw = rw;
            hw = r;

        } Muxselseg1[27:22] = 0x0;
        field {
            desc = "Mux Select Bits for Lane 2. Split debug bus into 16 bit segments. Seg0 = debug bus [15:0], Seg1 = debug bus[31:16],.... If all bits are 0, Lane2= Seg2, if bit[0] = 1, Lane2 = Seg4, if bit[1] =1, Lane2 = Seg5,...";
            sw = rw;
            hw = r;

        } Muxselseg2[33:28] = 0x0;
        field {
            desc = "Mux Select Bits for Lane 3. Split debug bus into 16 bit segments. Seg0 = debug bus [15:0], Seg1 = debug bus[31:16],.... If all bits are 0, Lane3= Seg3, if bit[0] = 1, Lane3 = Seg4, if bit[1] =1, Lane3 = Seg5,...";
            sw = rw;
            hw = r;

        } Muxselseg3[39:34] = 0x0;
        field {
            sw = rw;
            hw = r;

        } Muxselseg4[45:40] = 0x0;
        field {
            sw = rw;
            hw = r;

        } Muxselseg5[51:46] = 0x0;
        field {
            sw = rw;
            hw = r;

        } Muxselseg6[57:52] = 0x0;
        field {
            sw = rw;
            hw = r;

        } Muxselseg7[63:58] = 0x0;
    } CDbgMuxSel @ 0x198;
    reg {
        desc = "";
        regwidth = 0x40;

        field {
            sw = rw;
            hw = r;

        } DfdMmrLock[0:0] = 0x1;
        field {
            sw = r;
            hw = r;

        } Rsvd621[62:1] = 0x0;
        field {
            sw = rw;
            hw = r;

        } DfdEn[63:63] = 0x0;
    } CDfdCsr @ 0x1A0;

    reg {
        regwidth = 0x40;
        field {
            sw = rw;
            hw = rw;
            desc = "Timestamp value";
        } Timestamp[63:0] = 0x0;
    } Timestamp @ 0x200;

    reg {
        regwidth = 0x40;
        field {
            sw = rw;
            hw = r;
            desc = "TimestampSync value";
        } TimestampSync[63:0] = 0x0;
    } TimestampSync @ 0x208;

    reg {
        regwidth = 0x20;

        field {
            sw = rw;
            hw = r;
            desc = "TS Sync";
        } TsSync [0:0] = 0x0;
        field {
            sw = rw;
            hw = r;
            desc = "Debug Marker";
        } DebugMarker [8:1] = 0x0;
        field {
            sw = rw;
            hw = r;
            desc = "Rsvd";
        } Rsvd [31:9] = 0x0;
    } TimeStampConfig @ 0x210;

    reg {
        desc = "";
        regwidth = 0x20;

        field {
            sw = rw;
            hw = r;
        } Trdstactive[0:0] = 0x0;
        field {
            sw = rw;
            hw = r;
        } Trdstenable[1:1] = 0x0;
        field {
            sw = rw;
            hw = w;
        } Trdstinsttracing[2:2] = 0x0;
        field {
            sw = r;
            hw = w;
        } Trdstempty[3:3] = 0x1;
        field {
            sw = r;
            hw = r;
        } Trdstinstmode[6:4] = 0x6;
        field {
            sw = r;
            hw = r;
        } Trdstcontext[9:9] = 0x0;
        field {
            sw = rw;
            hw = r;
        } Trdstinsttriggerenable[11:11] = 0x0;
        field {
            sw = r;
            hw = r;
        } Trdstinststalloroverflow[12:12] = 0x0;
        field {
            sw = r;
            hw = r;
        } Trdstinststallena[13:13] = 0x0;
        field {
            sw = r;
            hw = r;
        } Trdstinhibitsrc[15:15] = 0x0;
        field {
            desc = "When the field is set tp 2'b10, sent timestamp. All other vlaues not NA.";
            sw = rw;
            hw = r;
        } Trdstsyncmode[17:16] = 0x0;
        field {
            desc = "When trDstSyncMode is set to 2'b10, timestamp will be sent for every 2^(trDstSyncMax + 4) Cluster clocks.";
            sw = rw;
            hw = r;
        } Trdstsyncmax[23:20] = 0x0;
        field {
            desc = "bit[0]: XOR Enable, bit[1]: VLT Enable. Supported values : 2'b3 (XOR+VLT Compression), 2'b1 (XOR Compresion), 2'b0 (No Compression)";
            sw = rw;
            hw = r;
        } Trdstformat[26:24] = 0x3;
    } Trdstcontrol @ 0x1000;
    reg {
        desc = "";
        regwidth = 0x20;

        field {
            sw = r;
            hw = r;
        } Trdstvermajor[3:0] = 0x1;
        field {
            sw = r;
            hw = r;
        } Trdstverminor[7:4] = 0x0;
        field {
            sw = r;
            hw = r;
        } Trdstcomptype[11:8] = 0x1;
        field {
            sw = r;
            hw = r;
        } Trdstprotocolmajor[19:16] = 0x1;
        field {
            sw = r;
            hw = r;
        } Trdstprotocolminor[23:20] = 0x0;
        field {
            desc = "Specify frame length. Frame Length = trDstVendorFrameLength* 64 ; Frame Length should be a multiple of Bank Data Width.";
            sw = rw;
            hw = r;
        } Trdstvendorframelength[27:24] = 0x1;
        field {
            desc = "Specify Stream length. A stream starts with \"no compressed packet\". Stream length specifies number of frames before a non-compressed packet is sent.Stream Length = 32* 2^(trDstVendorStreamLength + 1)";
            sw = rw;
            hw = r;
        } Trdstvendorstreamlength[30:28] = 0x4;
    } Trdstimpl @ 0x1004;
    reg {
        desc = "";
        regwidth = 0x20;

        field {
            sw = r;
            hw = r;
        } Trdstinstnoaddrdiff[0:0] = 0x0;
        field {
            sw = r;
            hw = r;
        } Trdstinstnotrapaddr[1:1] = 0x0;
        field {
            sw = r;
            hw = r;
        } Trdstinstenrepeatedhistory[8:8] = 0x0;
        field {
            sw = rw;
            hw = r;
        } Trdstsrcid[27:16] = 0x0;
        field {
            sw = rw;
            hw = r;
        } Trdstsrcbits[31:28] = 0x4;
    } Trdstinstfeatures @ 0x1008;
    reg {
        desc = "";
        regwidth = 0x20;

        field {
            desc = "Trace Source ID (FIXME: Base Address, Tool Issue)";
            sw = rw;
            hw = r;
        } TraceSourceId[3:0] = 0x0;
        field {
            desc = "Use \"Filler Packet\" to align a stream of trace packets within a frame boundary.";
            sw = rw;
            hw = r;
        } TraceFrameFillByte[11:4] = 0x81;
        field {
            desc = "Use trDstImpl[trDstVendorFrameLength] for Frame Length programming. Register field ZBB-ed.";
            sw = rw;
            hw = r;
        } FrameLenghtInBytes[15:12] = 0x2;
        field {
            desc = "Enable Frame Mode (Frame Mode: Always pack \"frame length\" number of bytes for trace transmission). If flush to memory is stalled (due to silicon bug), we can have incomplete packets in memory. Frame Mode will help SW decoder to avoid reading incomplete trasnmitted packets. In Frame Mode, SW will get a memory pointer that is aligned to Frame Length. HW will ensure  there are no incomplete packets incluced in the region pointed by memory pointer.";
            sw = rw;
            hw = r;
        } FrameModeEnable[20:20] = 0x1;
        field {
            desc = "Closure Mode: 1: Close frame with a packet no larger than max packet size  before any overflow (due to packets crossing frame boundary). 0: Close frame when packets cross boundary. Push back packet crossing frame boundary to packet generator.";
            sw = rw;
            hw = r;
        } FrameClosureMode[21:21] = 0x1;
    } CDbgDebugTraceCfg @ 0x11A0;

    reg {
        desc = "Configure CLA counter0. One of the 4 counters used for counting cycles after a event match, and trigger a action on match.";
        regwidth = 0x40;

        field {
            sw = rw;
            hw = w;

        } Counter[15:0] = 0x0;
        field {
            sw = rw;
            hw = r;

        } Target[31:16] = 0x0;
        field {
            desc = "When Counter = {upper_target,target} reset to 0.  With this bit set, counter will provide a periodic tick w/ frequency of (target +1) if the action is set to Auto Incr. The periodic tick will continue till Stop Auto Incr or Clear Counter action.";
            sw = rw;
            hw = r;

        } ResetOnTarget[32:32] = 0x0;
        field {
            sw = rw;
            hw = w;

        } UpperCounter[47:33] = 0x0;
        field {
            sw = rw;
            hw = r;

        } UpperTarget[62:48] = 0x0;
        field {
            sw = r;
            hw = r;


        } Rsvd[63:63] = 0x0;
    } CDbgClaCounter0Cfg @ 0x3100;
    reg {
        desc = "Configure CLA counter1. One of the 4 counters used for counting cycles after a event match, and trigger a action on match.";
        regwidth = 0x40;

        field {
            sw = rw;
            hw = w;

        } Counter[15:0] = 0x0;
        field {
            sw = rw;
            hw = r;

        } Target[31:16] = 0x0;
        field {
            desc = "When Counter = {upper_targe,target}, reset to 0.  With this bit set, counter will provide a periodic tick w/ frequency of (target +1) if the action is set to Auto Incr. The periodic tick will continue till Stop Auto Incr or Clear Counter action.";
            sw = rw;
            hw = r;

        } ResetOnTarget[32:32] = 0x0;
        field {
            sw = rw;
            hw = w;

        } UpperCounter[47:33] = 0x0;
        field {
            sw = rw;
            hw = r;

        } UpperTarget[62:48] = 0x0;
        field {
            sw = r;
            hw = r;


        } Rsvd[63:63] = 0x0;
    } CDbgClaCounter1Cfg @ 0x3108;
    reg {
        desc = "Configure CLA counter2. One of the 4 counters used for counting cycles after a event match, and trigger a action on match.";
        regwidth = 0x40;

        field {
            sw = rw;
            hw = w;

        } Counter[15:0] = 0x0;
        field {
            sw = rw;
            hw = r;

        } Target[31:16] = 0x0;
        field {
            desc = "When Counter = {upper_target,target}, reset to 0.  With this bit set, counter will provide a periodic tick w/ frequency of (target +1) if the action is set to Auto Incr. The periodic tick will continue till Stop Auto Incr or Clear Counter action.";
            sw = rw;
            hw = r;

        } ResetOnTarget[32:32] = 0x0;
        field {
            sw = rw;
            hw = w;

        } UpperCounter[47:33] = 0x0;
        field {
            sw = rw;
            hw = r;

        } UpperTarget[62:48] = 0x0;
        field {
            sw = r;
            hw = r;


        } Rsvd[63:63] = 0x0;
    } CDbgClaCounter2Cfg @ 0x3110;
    reg {
        desc = "Configure CLA counter3. One of the 4 counters used for counting cycles after a event match, and trigger a action on match.";
        regwidth = 0x40;

        field {
            sw = rw;
            hw = w;

        } Counter[15:0] = 0x0;
        field {
            sw = rw;
            hw = r;

        } Target[31:16] = 0x0;
        field {
            desc = "When Counter = {upper_target,target}, reset to 0.  With this bit set, counter will provide a periodic tick w/ frequency of (target +1) if the action is set to Auto Incr. The periodic tick will continue till Stop Auto Incr or Clear Counter action.";
            sw = rw;
            hw = r;

        } ResetOnTarget[32:32] = 0x0;
        field {
            sw = rw;
            hw = w;

        } UpperCounter[47:33] = 0x0;
        field {
            sw = rw;
            hw = r;

        } UpperTarget[62:48] = 0x0;
        field {
            sw = r;
            hw = r;


        } Rsvd[63:63] = 0x0;
    } CDbgClaCounter3Cfg @ 0x3118;
    reg {
        desc = "CLA Action(s) are tied to events(s) using \"event-action pairing\" registers. One of he 8 EAPs (Two EAPs per Node).";
        regwidth = 0x40;

        field {
            desc = "Select Destination Node";
            sw = rw;
            hw = r;

        } DestNode[1:0] = 0x0;
        field {
            desc = "Select an Action";
            sw = rw;
            hw = r;

        } Action0[7:2] = 0x0;
        field {
            desc = "Select an Action";
            sw = rw;
            hw = r;

        } Action1[13:8] = 0x0;
        field {
            desc = "Relation to be satisfied among events to activate the actions";
            sw = rw;
            hw = r;

        } LogicalOp[15:14] = 0x0;
        field {
            desc = "Select a trigger event";
            sw = rw;
            hw = r;

        } EventType0[21:16] = 0x0;
        field {
            desc = "Select a trigger event";
            sw = rw;
            hw = r;

        } EventType1[27:22] = 0x0;
        field {
            desc = "Select the bit position of custom action bus to be set when EAP trigger is met. External blocks can define and implement the specifc action for a given bit.";
            sw = rw;
            hw = r;

        } CustomAction0[31:28] = 0x0;
        field {
            desc = "Select the bit position of custom action bus to be set when EAP trigger is met. External blocks can define and implement the specifc action for a given bit.";
            sw = rw;
            hw = r;

        } CustomAction1[35:32] = 0x0;
        field {
            desc = "custom_action0 is valid only if custom_action0_enable is set";
            sw = rw;
            hw = r;

        } CustomAction0Enable[36:36] = 0x0;
        field {
            desc = "custom_action1 is valid only if custom_action1_enable is set";
            sw = rw;
            hw = r;

        } CustomAction1Enable[37:37] = 0x0;
        field {
            desc = "Select a trigger event";
            sw = rw;
            hw = r;

        } EventType2[43:38] = 0x0;
        field {
            desc = "User Defined Function with event type 0, 1, and 2 as arguments";
            sw = rw;
            hw = r;

        } Udf[51:44] = 0x0;
        field {
            sw = rw;
            hw = r;

        } Rsvd[63:52] = 0x0;
    } CDbgNode0Eap0 @ 0x3120;
    reg {
        desc = "CLA Action(s) are tied to events(s) using \"event-action pairing\" registers. One of he 8 EAPs (Two EAPs per Node).";
        regwidth = 0x40;

        field {
            desc = "Select Destination Node";
            sw = rw;
            hw = r;

        } DestNode[1:0] = 0x0;
        field {
            desc = "Select an Action";
            sw = rw;
            hw = r;

        } Action0[7:2] = 0x0;
        field {
            desc = "Select an Action";
            sw = rw;
            hw = r;

        } Action1[13:8] = 0x0;
        field {
            desc = "Relation to be satisfied among events to activate the actions";
            sw = rw;
            hw = r;

        } LogicalOp[15:14] = 0x0;
        field {
            desc = "Select a trigger event";
            sw = rw;
            hw = r;

        } EventType0[21:16] = 0x0;
        field {
            desc = "Select a trigger event";
            sw = rw;
            hw = r;

        } EventType1[27:22] = 0x0;
        field {
            desc = "Select the bit position of custom action bus to be set when EAP trigger is met. External blocks can define and implement the specifc action for a given bit.";
            sw = rw;
            hw = r;

        } CustomAction0[31:28] = 0x0;
        field {
            desc = "Select the bit position of custom action bus to be set when EAP trigger is met. External blocks can define and implement the specifc action for a given bit.";
            sw = rw;
            hw = r;

        } CustomAction1[35:32] = 0x0;
        field {
            desc = "custom_action0 is valid only if custom_action0_enable is set";
            sw = rw;
            hw = r;

        } CustomAction0Enable[36:36] = 0x0;
        field {
            desc = "custom_action1 is valid only if custom_action1_enable is set";
            sw = rw;
            hw = r;

        } CustomAction1Enable[37:37] = 0x0;
        field {
            desc = "Select a trigger event";
            sw = rw;
            hw = r;

        } EventType2[43:38] = 0x0;
        field {
            desc = "User Defined Function with event type 0, 1, and 2 as arguments";
            sw = rw;
            hw = r;

        } Udf[51:44] = 0x0;
        field {
            sw = rw;
            hw = r;

        } Rsvd[63:52] = 0x0;
    } CDbgNode0Eap1 @ 0x3128;
    reg {
        desc = "CLA Action(s) are tied to events(s) using \"event-action pairing\" registers. One of he 8 EAPs (Two EAPs per Node).";
        regwidth = 0x40;

        field {
            desc = "Select Destination Node";
            sw = rw;
            hw = r;

        } DestNode[1:0] = 0x0;
        field {
            desc = "Select an Action";
            sw = rw;
            hw = r;

        } Action0[7:2] = 0x0;
        field {
            desc = "Select an Action";
            sw = rw;
            hw = r;

        } Action1[13:8] = 0x0;
        field {
            desc = "Relation to be satisfied among events to activate the actions";
            sw = rw;
            hw = r;

        } LogicalOp[15:14] = 0x0;
        field {
            desc = "Select a trigger event";
            sw = rw;
            hw = r;

        } EventType0[21:16] = 0x0;
        field {
            desc = "Select a trigger event";
            sw = rw;
            hw = r;

        } EventType1[27:22] = 0x0;
        field {
            desc = "Select the bit position of custom action bus to be set when EAP trigger is met. External blocks can define and implement the specifc action for a given bit.";
            sw = rw;
            hw = r;

        } CustomAction0[31:28] = 0x0;
        field {
            desc = "Select the bit position of custom action bus to be set when EAP trigger is met. External blocks can define and implement the specifc action for a given bit.";
            sw = rw;
            hw = r;

        } CustomAction1[35:32] = 0x0;
        field {
            desc = "custom_action0 is valid only if custom_action0_enable is set";
            sw = rw;
            hw = r;

        } CustomAction0Enable[36:36] = 0x0;
        field {
            desc = "custom_action1 is valid only if custom_action1_enable is set";
            sw = rw;
            hw = r;

        } CustomAction1Enable[37:37] = 0x0;
        field {
            desc = "Select a trigger event";
            sw = rw;
            hw = r;

        } EventType2[43:38] = 0x0;
        field {
            desc = "User Defined Function with event type 0, 1, and 2 as arguments";
            sw = rw;
            hw = r;

        } Udf[51:44] = 0x0;
        field {
            sw = rw;
            hw = r;

        } Rsvd[63:52] = 0x0;
    } CDbgNode1Eap0 @ 0x3130;
    reg {
        desc = "CLA Action(s) are tied to events(s) using \"event-action pairing\" registers. One of he 8 EAPs (Two EAPs per Node).";
        regwidth = 0x40;

        field {
            desc = "Select Destination Node";
            sw = rw;
            hw = r;

        } DestNode[1:0] = 0x0;
        field {
            desc = "Select an Action";
            sw = rw;
            hw = r;

        } Action0[7:2] = 0x0;
        field {
            desc = "Select an Action";
            sw = rw;
            hw = r;

        } Action1[13:8] = 0x0;
        field {
            desc = "Relation to be satisfied among events to activate the actions";
            sw = rw;
            hw = r;

        } LogicalOp[15:14] = 0x0;
        field {
            desc = "Select a trigger event";
            sw = rw;
            hw = r;

        } EventType0[21:16] = 0x0;
        field {
            desc = "Select a trigger event";
            sw = rw;
            hw = r;

        } EventType1[27:22] = 0x0;
        field {
            desc = "Select the bit position of custom action bus to be set when EAP trigger is met. External blocks can define and implement the specifc action for a given bit.";
            sw = rw;
            hw = r;

        } CustomAction0[31:28] = 0x0;
        field {
            desc = "Select the bit position of custom action bus to be set when EAP trigger is met. External blocks can define and implement the specifc action for a given bit.";
            sw = rw;
            hw = r;

        } CustomAction1[35:32] = 0x0;
        field {
            desc = "custom_action0 is valid only if custom_action0_enable is set";
            sw = rw;
            hw = r;

        } CustomAction0Enable[36:36] = 0x0;
        field {
            desc = "custom_action1 is valid only if custom_action1_enable is set";
            sw = rw;
            hw = r;

        } CustomAction1Enable[37:37] = 0x0;
        field {
            desc = "Select a trigger event";
            sw = rw;
            hw = r;

        } EventType2[43:38] = 0x0;
        field {
            desc = "User Defined Function with event type 0, 1, and 2 as arguments";
            sw = rw;
            hw = r;

        } Udf[51:44] = 0x0;
        field {
            sw = rw;
            hw = r;

        } Rsvd[63:52] = 0x0;
    } CDbgNode1Eap1 @ 0x3138;
    reg {
        desc = "CLA Action(s) are tied to events(s) using \"event-action pairing\" registers. One of he 8 EAPs (Two EAPs per Node).";
        regwidth = 0x40;

        field {
            desc = "Select Destination Node";
            sw = rw;
            hw = r;

        } DestNode[1:0] = 0x0;
        field {
            desc = "Select an Action";
            sw = rw;
            hw = r;

        } Action0[7:2] = 0x0;
        field {
            desc = "Select an Action";
            sw = rw;
            hw = r;

        } Action1[13:8] = 0x0;
        field {
            desc = "Relation to be satisfied among events to activate the actions";
            sw = rw;
            hw = r;

        } LogicalOp[15:14] = 0x0;
        field {
            desc = "Select a trigger event";
            sw = rw;
            hw = r;

        } EventType0[21:16] = 0x0;
        field {
            desc = "Select a trigger event";
            sw = rw;
            hw = r;

        } EventType1[27:22] = 0x0;
        field {
            desc = "Select the bit position of custom action bus to be set when EAP trigger is met. External blocks can define and implement the specifc action for a given bit.";
            sw = rw;
            hw = r;

        } CustomAction0[31:28] = 0x0;
        field {
            desc = "Select the bit position of custom action bus to be set when EAP trigger is met. External blocks can define and implement the specifc action for a given bit.";
            sw = rw;
            hw = r;

        } CustomAction1[35:32] = 0x0;
        field {
            desc = "custom_action0 is valid only if custom_action0_enable is set";
            sw = rw;
            hw = r;

        } CustomAction0Enable[36:36] = 0x0;
        field {
            desc = "custom_action1 is valid only if custom_action1_enable is set";
            sw = rw;
            hw = r;

        } CustomAction1Enable[37:37] = 0x0;
        field {
            desc = "Select a trigger event";
            sw = rw;
            hw = r;

        } EventType2[43:38] = 0x0;
        field {
            desc = "User Defined Function with event type 0, 1, and 2 as arguments";
            sw = rw;
            hw = r;

        } Udf[51:44] = 0x0;
        field {
            sw = rw;
            hw = r;

        } Rsvd[63:52] = 0x0;
    } CDbgNode2Eap0 @ 0x3140;
    reg {
        desc = "CLA Action(s) are tied to events(s) using \"event-action pairing\" registers. One of he 8 EAPs (Two EAPs per Node).";
        regwidth = 0x40;

        field {
            desc = "Select Destination Node";
            sw = rw;
            hw = r;

        } DestNode[1:0] = 0x0;
        field {
            desc = "Select an Action";
            sw = rw;
            hw = r;

        } Action0[7:2] = 0x0;
        field {
            desc = "Select an Action";
            sw = rw;
            hw = r;

        } Action1[13:8] = 0x0;
        field {
            desc = "Relation to be satisfied among events to activate the actions";
            sw = rw;
            hw = r;

        } LogicalOp[15:14] = 0x0;
        field {
            desc = "Select a trigger event";
            sw = rw;
            hw = r;

        } EventType0[21:16] = 0x0;
        field {
            desc = "Select a trigger event";
            sw = rw;
            hw = r;

        } EventType1[27:22] = 0x0;
        field {
            desc = "Select the bit position of custom action bus to be set when EAP trigger is met. External blocks can define and implement the specifc action for a given bit.";
            sw = rw;
            hw = r;

        } CustomAction0[31:28] = 0x0;
        field {
            desc = "Select the bit position of custom action bus to be set when EAP trigger is met. External blocks can define and implement the specifc action for a given bit.";
            sw = rw;
            hw = r;

        } CustomAction1[35:32] = 0x0;
        field {
            desc = "custom_action0 is valid only if custom_action0_enable is set";
            sw = rw;
            hw = r;

        } CustomAction0Enable[36:36] = 0x0;
        field {
            desc = "custom_action1 is valid only if custom_action1_enable is set";
            sw = rw;
            hw = r;

        } CustomAction1Enable[37:37] = 0x0;
        field {
            desc = "Select a trigger event";
            sw = rw;
            hw = r;

        } EventType2[43:38] = 0x0;
        field {
            desc = "User Defined Function with event type 0, 1, and 2 as arguments";
            sw = rw;
            hw = r;

        } Udf[51:44] = 0x0;
        field {
            sw = rw;
            hw = r;

        } Rsvd[63:52] = 0x0;
    } CDbgNode2Eap1 @ 0x3148;
    reg {
        desc = "CLA Action(s) are tied to events(s) using \"event-action pairing\" registers. One of he 8 EAPs (Two EAPs per Node).";
        regwidth = 0x40;

        field {
            desc = "Select Destination Node";
            sw = rw;
            hw = r;

        } DestNode[1:0] = 0x0;
        field {
            desc = "Select an Action";
            sw = rw;
            hw = r;

        } Action0[7:2] = 0x0;
        field {
            desc = "Select an Action";
            sw = rw;
            hw = r;

        } Action1[13:8] = 0x0;
        field {
            desc = "Relation to be satisfied among events to activate the actions";
            sw = rw;
            hw = r;

        } LogicalOp[15:14] = 0x0;
        field {
            desc = "Select a trigger event";
            sw = rw;
            hw = r;

        } EventType0[21:16] = 0x0;
        field {
            desc = "Select a trigger event";
            sw = rw;
            hw = r;

        } EventType1[27:22] = 0x0;
        field {
            desc = "Select the bit position of custom action bus to be set when EAP trigger is met. External blocks can define and implement the specifc action for a given bit.";
            sw = rw;
            hw = r;

        } CustomAction0[31:28] = 0x0;
        field {
            desc = "Select the bit position of custom action bus to be set when EAP trigger is met. External blocks can define and implement the specifc action for a given bit.";
            sw = rw;
            hw = r;

        } CustomAction1[35:32] = 0x0;
        field {
            desc = "custom_action0 is valid only if custom_action0_enable is set";
            sw = rw;
            hw = r;

        } CustomAction0Enable[36:36] = 0x0;
        field {
            desc = "custom_action1 is valid only if custom_action1_enable is set";
            sw = rw;
            hw = r;

        } CustomAction1Enable[37:37] = 0x0;
        field {
            desc = "Select a trigger event";
            sw = rw;
            hw = r;

        } EventType2[43:38] = 0x0;
        field {
            desc = "User Defined Function with event type 0, 1, and 2 as arguments";
            sw = rw;
            hw = r;

        } Udf[51:44] = 0x0;
        field {
            sw = rw;
            hw = r;

        } Rsvd[63:52] = 0x0;
    } CDbgNode3Eap0 @ 0x3150;
    reg {
        desc = "CLA Action(s) are tied to events(s) using \"event-action pairing\" registers. One of he 8 EAPs (Two EAPs per Node).";
        regwidth = 0x40;

        field {
            desc = "Select Destination Node";
            sw = rw;
            hw = r;

        } DestNode[1:0] = 0x0;
        field {
            desc = "Select an Action";
            sw = rw;
            hw = r;

        } Action0[7:2] = 0x0;
        field {
            desc = "Select an Action";
            sw = rw;
            hw = r;

        } Action1[13:8] = 0x0;
        field {
            desc = "Relation to be satisfied among events to activate the actions";
            sw = rw;
            hw = r;

        } LogicalOp[15:14] = 0x0;
        field {
            desc = "Select a trigger event";
            sw = rw;
            hw = r;

        } EventType0[21:16] = 0x0;
        field {
            desc = "Select a trigger event";
            sw = rw;
            hw = r;

        } EventType1[27:22] = 0x0;
        field {
            desc = "Select the bit position of custom action bus to be set when EAP trigger is met. External blocks can define and implement the specifc action for a given bit.";
            sw = rw;
            hw = r;

        } CustomAction0[31:28] = 0x0;
        field {
            desc = "Select the bit position of custom action bus to be set when EAP trigger is met. External blocks can define and implement the specifc action for a given bit.";
            sw = rw;
            hw = r;

        } CustomAction1[35:32] = 0x0;
        field {
            desc = "custom_action0 is valid only if custom_action0_enable is set";
            sw = rw;
            hw = r;

        } CustomAction0Enable[36:36] = 0x0;
        field {
            desc = "custom_action1 is valid only if custom_action1_enable is set";
            sw = rw;
            hw = r;

        } CustomAction1Enable[37:37] = 0x0;
        field {
            desc = "Select a trigger event";
            sw = rw;
            hw = r;

        } EventType2[43:38] = 0x0;
        field {
            desc = "User Defined Function with event type 0, 1, and 2 as arguments";
            sw = rw;
            hw = r;

        } Udf[51:44] = 0x0;
        field {
            sw = rw;
            hw = r;

        } Rsvd[63:52] = 0x0;
    } CDbgNode3Eap1 @ 0x3158;
    reg {
        desc = "Used to define debug bus match event. Match event (0x2) is triggered when debug_bus & mask = match.";
        regwidth = 0x40;

        field {
            desc = "Mask to be applied to debug bus before match";
            sw = rw;
            hw = r;

        } Value[63:0] = 0x0;
    } CDbgSignalMask0 @ 0x3160;
    reg {
        desc = "Used to define debug bus match event. Match event (0x2) is triggered when debug_bus & mask = match.";
        regwidth = 0x40;

        field {
            desc = "Value used for debug bus match.";
            sw = rw;
            hw = r;

        } Value[63:0] = 0x0;
    } CDbgSignalMatch0 @ 0x3168;
    reg {
        desc = "Used to define debug bus match event. Match event (0x4) is triggered when debug_bus & mask = match.";
        regwidth = 0x40;

        field {
            desc = "Mask to be applied to debug bus before match";
            sw = rw;
            hw = r;

        } Value[63:0] = 0x0;
    } CDbgSignalMask1 @ 0x3170;
    reg {
        desc = "Used to define debug bus match event. Match event (0x4) is triggered when debug_bus & mask = match.";
        regwidth = 0x40;

        field {
            desc = "Value used for debug bus match.";
            sw = rw;
            hw = r;

        } Value[63:0] = 0x0;
    } CDbgSignalMatch1 @ 0x3178;
    reg {
        desc = "Register to configure debug bus for edge triggers.";
        regwidth = 0x40;

        field {
            desc = "Define which signal to select for edge detection.";
            sw = rw;
            hw = r;

        } Signal0Select[5:0] = 0x0;
        field {
            desc = "Defines which edge to detect for singal from signal0_select. 1: Pos edge, 0: Neg Edge";
            sw = rw;
            hw = r;

        } PosEdgeSignal0[6:6] = 0x0;
        field {
            desc = "Define which signal to select for edge detection.";
            sw = rw;
            hw = r;

        } Signal1Select[12:7] = 0x0;
        field {
            desc = "Defines which edge to detect for singal from signal1_select. 1: Pos edge, 0: Neg Edge";
            sw = rw;
            hw = r;

        } PosEdgeSignal1[13:13] = 0x0;
    } CDbgSignalEdgeDetectCfg @ 0x3180;
    reg {
        desc = "Register to indicate if EAP Pair was activated. Use the corresponding w2c register to reset the status. There are 2 bits for each EAP. The bit corresponds to action-0 and action-1 of the EAP. The register is used by SW to know if an action was taken (ex: NMI ISR needs to know which of the EAP triggered the NMI)";
        regwidth = 0x40;

        field {
            sw = r;
            hw = rw;

        } Node0Eap0[0:0] = 0x0;
        field {
            sw = r;
            hw = rw;

        } Node0Eap1[1:1] = 0x0;
        field {
            sw = r;
            hw = rw;

        } Node1Eap0[2:2] = 0x0;
        field {
            sw = r;
            hw = rw;

        } Node1Eap1[3:3] = 0x0;
        field {
            sw = r;
            hw = rw;

        } Node2Eap0[4:4] = 0x0;
        field {
            sw = r;
            hw = rw;

        } Node2Eap1[5:5] = 0x0;
        field {
            sw = r;
            hw = rw;

        } Node3Eap0[6:6] = 0x0;
        field {
            sw = r;
            hw = rw;

        } Node3Eap1[7:7] = 0x0;
        field {
            sw = r;
            hw = rw;

        } Rsvd318[31:8] = 0x0;
        field {
            sw = rw;
            hw = rw;

        } Node0Eap0W2C[32:32] = 0x0;
        field {
            sw = rw;
            hw = rw;

        } Node0Eap1W2C[33:33] = 0x0;
        field {
            sw = rw;
            hw = rw;

        } Node1Eap0W2C[34:34] = 0x0;
        field {
            sw = rw;
            hw = rw;

        } Node1Eap1W2C[35:35] = 0x0;
        field {
            sw = rw;
            hw = rw;

        } Node2Eap0W2C[36:36] = 0x0;
        field {
            sw = rw;
            hw = rw;

        } Node2Eap1W2C[37:37] = 0x0;
        field {
            sw = rw;
            hw = rw;

        } Node3Eap0W2C[38:38] = 0x0;
        field {
            sw = rw;
            hw = rw;

        } Node3Eap1W2C[39:39] = 0x0;
    } CDbgEapStatus @ 0x3188;
    reg {
        desc = "Ctrl/Status register to Enable EAP after EAP programming is complete, and read the current node.";
        regwidth = 0x40;

        field {
            desc = "Read the current node.";
            sw = r;
            hw = w;

        } CurrentNode[1:0] = 0x0;
        field {
            desc = "Set Enable EAP to 1 after EAP programming is complete";
            sw = rw;
            hw = r;

        } EnableEap[5:5] = 0x0;
        field {
            desc = "Set this bit to 1 to enable CLA. If this bit is set, CLA is clock gated (save pwr)";
            sw = rw;
            hw = r;

        } EnableCla[6:6] = 0x0;
        field {
            desc = "Creates a window in which we don’t forward the incoming Xtrigger and Clock_Halt signal";
            sw = rw;
            hw = r;

        } ClaChainLoopDelay[13:7] = 0x36;
        field {
            desc = "If this bit is set, clock halt action is not applied to global clocks";
            sw = rw;
            hw = r;

        } DisableGlobalClockHalt[14:14] = 0x0;
        field {
            desc = "If this bit is set, clock halt action is not applied to local clocks";
            sw = rw;
            hw = r;

        } DisableLocalClockHalt[15:15] = 0x0;
    } CDbgClaCtrlStatus @ 0x3190;
    reg {
        desc = "Reserved Register that can be changed.";
        regwidth = 0x40;

        field {
            desc = "Value of reserved register.";
            sw = rw;
            hw = r;

        } Value[63:0] = 0x0;
    } CDbgRsvd0 @ 0x3198;
    reg {
        desc = "Reserved Register that can be changed.";
        regwidth = 0x40;

        field {
            desc = "Value of reserved register.";
            sw = rw;
            hw = r;

        } Value[63:0] = 0x0;
    } CDbgRsvd1 @ 0x31A0;
    reg {
        desc = "Reserved Register that can be changed.";
        regwidth = 0x40;

        field {
            desc = "Value of reserved register.";
            sw = rw;
            hw = r;

        } Value[63:0] = 0x0;
    } CDbgRsvd2 @ 0x31A8;
    reg {
        desc = "3 registers to configure \"transition event\". This register is to select the signals of interest using a mask.";
        regwidth = 0x40;

        field {
            sw = rw;
            hw = r;

        } Value[63:0] = 0x0;
    } CDbgTransitionMask @ 0x31B0;
    reg {
        desc = "3 registers to configure \"transition event\". The event is triggered on transition from Value A to Value B. This register specifies Value A.";
        regwidth = 0x40;

        field {
            sw = rw;
            hw = r;

        } Value[63:0] = 0x0;
    } CDbgTransitionFromValue @ 0x31B8;
    reg {
        desc = "3 registers to configure \"transition event\". The event is triggered on transition from Value A to Value B. This register specifies Value B.";
        regwidth = 0x40;

        field {
            sw = rw;
            hw = r;

        } Value[63:0] = 0x0;
    } CDbgTransitionToValue @ 0x31C0;
    reg {
        desc = "2 registers to configure \"ones count\" event. This register is to select the signals of interest using a mask.";
        regwidth = 0x40;

        field {
            sw = rw;
            hw = r;

        } Value[63:0] = 0x0;
    } CDbgOnesCountMask @ 0x31C8;
    reg {
        desc = "2 registers to configure \"ones count\" event. Event triggered when the sum of the signals match the value specified in this register.";
        regwidth = 0x40;

        field {
            sw = rw;
            hw = r;

        } Value[63:0] = 0x0;
    } CDbgOnesCountValue @ 0x31D0;
    reg {
        desc = "Event triggered when a subset of debug signals change. The mask is used to select the subset of the debug signals.";
        regwidth = 0x40;

        field {
            sw = rw;
            hw = r;

        } Mask[63:0] = 0x0;
    } CDbgAnyChange @ 0x31D8;
    reg {
        desc = "debug Bus Value when Node0 Eap0 Trigger is met.";
        regwidth = 0x40;

        field {
            sw = r;
            hw = w;

        } Value[63:0] = 0x0;
    } CDbgSignalSnapshotNode0Eap0 @ 0x31E0;
    reg {
        desc = "debug Bus Value when Node0 Eap1 Trigger is met.";
        regwidth = 0x40;

        field {
            sw = r;
            hw = w;

        } Value[63:0] = 0x0;
    } CDbgSignalSnapshotNode0Eap1 @ 0x31E8;
    reg {
        desc = "debug Bus Value when Node1 Eap0 Trigger is met.";
        regwidth = 0x40;

        field {
            sw = r;
            hw = w;

        } Value[63:0] = 0x0;
    } CDbgSignalSnapshotNode1Eap0 @ 0x31F0;
    reg {
        desc = "debug Bus Value when Node1 Eap0 Trigger is met.";
        regwidth = 0x40;

        field {
            sw = r;
            hw = w;

        } Value[63:0] = 0x0;
    } CDbgSignalSnapshotNode1Eap1 @ 0x31F8;
    reg {
        desc = "debug Bus Value when Node0 Eap0 Trigger is met.";
        regwidth = 0x40;

        field {
            sw = r;
            hw = w;

        } Value[63:0] = 0x0;
    } CDbgSignalSnapshotNode2Eap0 @ 0x3200;
    reg {
        desc = "debug Bus Value when Node0 Eap1 Trigger is met.";
        regwidth = 0x40;

        field {
            sw = r;
            hw = w;

        } Value[63:0] = 0x0;
    } CDbgSignalSnapshotNode2Eap1 @ 0x3208;
    reg {
        desc = "debug Bus Value when Node1 Eap0 Trigger is met.";
        regwidth = 0x40;

        field {
            sw = r;
            hw = w;

        } Value[63:0] = 0x0;
    } CDbgSignalSnapshotNode3Eap0 @ 0x3210;
    reg {
        desc = "debug Bus Value when Node1 Eap0 Trigger is met.";
        regwidth = 0x40;

        field {
            sw = r;
            hw = w;

        } Value[63:0] = 0x0;
    } CDbgSignalSnapshotNode3Eap1 @ 0x3218;
    reg {
        desc = "This value is compared (greater than or equal to the programmed value) against the internal time register value of the core, and is used to generate a time match event for CLA. Needs to be non zero for the time match event signal to trigger. The event will only trigger an action if the EAP programming is done. Requires writing 0 to this register to stop the match event.";
        regwidth = 0x40;

        field {
            sw = rw;
            hw = r;

        } TimeMatchVal[63:0] = 0x0;
    } CDbgClaTimeMatch @ 0x3220;
    reg {
        desc = "Used to define debug bus match event. Match event (0x1C) is triggered when debug_bus & mask = match.";
        regwidth = 0x40;

        field {
            desc = "Mask to be applied to debug bus before match";
            sw = rw;
            hw = r;

        } Value[63:0] = 0x0;
    } CDbgSignalMask2 @ 0x3228;
    reg {
        desc = "Used to define debug bus match event. Match event (0x1C) is triggered when debug_bus & mask = match.";
        regwidth = 0x40;

        field {
            desc = "Value used for debug bus match.";
            sw = rw;
            hw = r;

        } Value[63:0] = 0x0;
    } CDbgSignalMatch2 @ 0x3230;
    reg {
        desc = "Used to define debug bus match event. Match event (0x1D) is triggered when debug_bus & mask = match.";
        regwidth = 0x40;

        field {
            desc = "Mask to be applied to debug bus before match";
            sw = rw;
            hw = r;

        } Value[63:0] = 0x0;
    } CDbgSignalMask3 @ 0x3238;
    reg {
        desc = "Used to define debug bus match event. Match event (0x1D) is triggered when debug_bus & mask = match.";
        regwidth = 0x40;

        field {
            desc = "Value used for debug bus match.";
            sw = rw;
            hw = r;

        } Value[63:0] = 0x0;
    } CDbgSignalMatch3 @ 0x3240;
    reg {
        desc = "CLA Action(s) are tied to events(s) using \"event-action pairing\" registers. One of he 8 EAPs (4 EAPs per Node).";
        regwidth = 0x40;
//         constraint_p = "";
        field {
            desc = "Select Destination Node";
            sw = rw;
            hw = r;
//             reset_port_p = "reset_n_warm_ovrride";
        } DestNode[1:0] = 0x0;
        field {
            desc = "Select an Action";
            sw = rw;
            hw = r;
//             reset_port_p = "reset_n_warm_ovrride";
        } Action0[7:2] = 0x0;
        field {
            desc = "Select an Action";
            sw = rw;
            hw = r;
//             reset_port_p = "reset_n_warm_ovrride";
        } Action1[13:8] = 0x0;
        field {
            desc = "Relation to be satisfied among events to activate the actions";
            sw = rw;
            hw = r;
//             reset_port_p = "reset_n_warm_ovrride";
        } LogicalOp[15:14] = 0x0;
        field {
            desc = "Select a trigger event";
            sw = rw;
            hw = r;
//             reset_port_p = "reset_n_warm_ovrride";
        } EventType0[21:16] = 0x0;
        field {
            desc = "Select a trigger event";
            sw = rw;
            hw = r;
//             reset_port_p = "reset_n_warm_ovrride";
        } EventType1[27:22] = 0x0;
        field {
            desc = "Select the bit position of custom action bus to be set when EAP trigger is met. External blocks can define and implement the specifc action for a given bit.";
            sw = rw;
            hw = r;
//             reset_port_p = "reset_n_warm_ovrride";
        } CustomAction0[31:28] = 0x0;
        field {
            desc = "Select the bit position of custom action bus to be set when EAP trigger is met. External blocks can define and implement the specifc action for a given bit.";
            sw = rw;
            hw = r;
//             reset_port_p = "reset_n_warm_ovrride";
        } CustomAction1[35:32] = 0x0;
        field {
            desc = "custom_action0 is valid only if custom_action0_enable is set";
            sw = rw;
            hw = r;
//             reset_port_p = "reset_n_warm_ovrride";
        } CustomAction0Enable[36:36] = 0x0;
        field {
            desc = "custom_action1 is valid only if custom_action1_enable is set";
            sw = rw;
            hw = r;
//             reset_port_p = "reset_n_warm_ovrride";
        } CustomAction1Enable[37:37] = 0x0;
        field {
            desc = "Select a trigger event";
            sw = rw;
            hw = r;
//             reset_port_p = "reset_n_warm_ovrride";
        } EventType2[43:38] = 0x0;
        field {
            desc = "User Defined Function with event type 0, 1, and 2 as arguments";
            sw = rw;
            hw = r;
//             reset_port_p = "reset_n_warm_ovrride";
        } Udf[51:44] = 0x0;
        field {
            desc = "Select an Action";
            sw = rw;
            hw = r;
//             reset_port_p = "reset_n_warm_ovrride";
        } Action2[57:52] = 0x0;
        field {
            desc = "Select an Action";
            sw = rw;
            hw = r;
//             reset_port_p = "reset_n_warm_ovrride";
        } Action3[63:58] = 0x0;
    } CDbgNode0Eap2 @ 0x3248;
    reg {
        desc = "CLA Action(s) are tied to events(s) using \"event-action pairing\" registers. One of he 8 EAPs (4 EAPs per Node).";
        regwidth = 0x40;
//         constraint_p = "";
        field {
            desc = "Select Destination Node";
            sw = rw;
            hw = r;
//             reset_port_p = "reset_n_warm_ovrride";
        } DestNode[1:0] = 0x0;
        field {
            desc = "Select an Action";
            sw = rw;
            hw = r;
//             reset_port_p = "reset_n_warm_ovrride";
        } Action0[7:2] = 0x0;
        field {
            desc = "Select an Action";
            sw = rw;
            hw = r;
//             reset_port_p = "reset_n_warm_ovrride";
        } Action1[13:8] = 0x0;
        field {
            desc = "Relation to be satisfied among events to activate the actions";
            sw = rw;
            hw = r;
//             reset_port_p = "reset_n_warm_ovrride";
        } LogicalOp[15:14] = 0x0;
        field {
            desc = "Select a trigger event";
            sw = rw;
            hw = r;
//             reset_port_p = "reset_n_warm_ovrride";
        } EventType0[21:16] = 0x0;
        field {
            desc = "Select a trigger event";
            sw = rw;
            hw = r;
//             reset_port_p = "reset_n_warm_ovrride";
        } EventType1[27:22] = 0x0;
        field {
            desc = "Select the bit position of custom action bus to be set when EAP trigger is met. External blocks can define and implement the specifc action for a given bit.";
            sw = rw;
            hw = r;
//             reset_port_p = "reset_n_warm_ovrride";
        } CustomAction0[31:28] = 0x0;
        field {
            desc = "Select the bit position of custom action bus to be set when EAP trigger is met. External blocks can define and implement the specifc action for a given bit.";
            sw = rw;
            hw = r;
//             reset_port_p = "reset_n_warm_ovrride";
        } CustomAction1[35:32] = 0x0;
        field {
            desc = "custom_action0 is valid only if custom_action0_enable is set";
            sw = rw;
            hw = r;
//             reset_port_p = "reset_n_warm_ovrride";
        } CustomAction0Enable[36:36] = 0x0;
        field {
            desc = "custom_action1 is valid only if custom_action1_enable is set";
            sw = rw;
            hw = r;
//             reset_port_p = "reset_n_warm_ovrride";
        } CustomAction1Enable[37:37] = 0x0;
        field {
            desc = "Select a trigger event";
            sw = rw;
            hw = r;
//             reset_port_p = "reset_n_warm_ovrride";
        } EventType2[43:38] = 0x0;
        field {
            desc = "User Defined Function with event type 0, 1, and 2 as arguments";
            sw = rw;
            hw = r;
//             reset_port_p = "reset_n_warm_ovrride";
        } Udf[51:44] = 0x0;
        field {
            desc = "Select an Action";
            sw = rw;
            hw = r;
//             reset_port_p = "reset_n_warm_ovrride";
        } Action2[57:52] = 0x0;
        field {
            desc = "Select an Action";
            sw = rw;
            hw = r;
//             reset_port_p = "reset_n_warm_ovrride";
        } Action3[63:58] = 0x0;
    } CDbgNode0Eap3 @ 0x3250;
    reg {
        desc = "CLA Action(s) are tied to events(s) using \"event-action pairing\" registers. One of he 8 EAPs (4 EAPs per Node).";
        regwidth = 0x40;
//         constraint_p = "";
        field {
            desc = "Select Destination Node";
            sw = rw;
            hw = r;
//             reset_port_p = "reset_n_warm_ovrride";
        } DestNode[1:0] = 0x0;
        field {
            desc = "Select an Action";
            sw = rw;
            hw = r;
//             reset_port_p = "reset_n_warm_ovrride";
        } Action0[7:2] = 0x0;
        field {
            desc = "Select an Action";
            sw = rw;
            hw = r;
//             reset_port_p = "reset_n_warm_ovrride";
        } Action1[13:8] = 0x0;
        field {
            desc = "Relation to be satisfied among events to activate the actions";
            sw = rw;
            hw = r;
//             reset_port_p = "reset_n_warm_ovrride";
        } LogicalOp[15:14] = 0x0;
        field {
            desc = "Select a trigger event";
            sw = rw;
            hw = r;
//             reset_port_p = "reset_n_warm_ovrride";
        } EventType0[21:16] = 0x0;
        field {
            desc = "Select a trigger event";
            sw = rw;
            hw = r;
//             reset_port_p = "reset_n_warm_ovrride";
        } EventType1[27:22] = 0x0;
        field {
            desc = "Select the bit position of custom action bus to be set when EAP trigger is met. External blocks can define and implement the specifc action for a given bit.";
            sw = rw;
            hw = r;
//             reset_port_p = "reset_n_warm_ovrride";
        } CustomAction0[31:28] = 0x0;
        field {
            desc = "Select the bit position of custom action bus to be set when EAP trigger is met. External blocks can define and implement the specifc action for a given bit.";
            sw = rw;
            hw = r;
//             reset_port_p = "reset_n_warm_ovrride";
        } CustomAction1[35:32] = 0x0;
        field {
            desc = "custom_action0 is valid only if custom_action0_enable is set";
            sw = rw;
            hw = r;
//             reset_port_p = "reset_n_warm_ovrride";
        } CustomAction0Enable[36:36] = 0x0;
        field {
            desc = "custom_action1 is valid only if custom_action1_enable is set";
            sw = rw;
            hw = r;
//             reset_port_p = "reset_n_warm_ovrride";
        } CustomAction1Enable[37:37] = 0x0;
        field {
            desc = "Select a trigger event";
            sw = rw;
            hw = r;
//             reset_port_p = "reset_n_warm_ovrride";
        } EventType2[43:38] = 0x0;
        field {
            desc = "User Defined Function with event type 0, 1, and 2 as arguments";
            sw = rw;
            hw = r;
//             reset_port_p = "reset_n_warm_ovrride";
        } Udf[51:44] = 0x0;
        field {
            desc = "Select an Action";
            sw = rw;
            hw = r;
//             reset_port_p = "reset_n_warm_ovrride";
        } Action2[57:52] = 0x0;
        field {
            desc = "Select an Action";
            sw = rw;
            hw = r;
//             reset_port_p = "reset_n_warm_ovrride";
        } Action3[63:58] = 0x0;
    } CDbgNode1Eap2 @ 0x3258;
    reg {
        desc = "CLA Action(s) are tied to events(s) using \"event-action pairing\" registers. One of he 8 EAPs (4 EAPs per Node).";
        regwidth = 0x40;
//         constraint_p = "";
        field {
            desc = "Select Destination Node";
            sw = rw;
            hw = r;
//             reset_port_p = "reset_n_warm_ovrride";
        } DestNode[1:0] = 0x0;
        field {
            desc = "Select an Action";
            sw = rw;
            hw = r;
//             reset_port_p = "reset_n_warm_ovrride";
        } Action0[7:2] = 0x0;
        field {
            desc = "Select an Action";
            sw = rw;
            hw = r;
//             reset_port_p = "reset_n_warm_ovrride";
        } Action1[13:8] = 0x0;
        field {
            desc = "Relation to be satisfied among events to activate the actions";
            sw = rw;
            hw = r;
//             reset_port_p = "reset_n_warm_ovrride";
        } LogicalOp[15:14] = 0x0;
        field {
            desc = "Select a trigger event";
            sw = rw;
            hw = r;
//             reset_port_p = "reset_n_warm_ovrride";
        } EventType0[21:16] = 0x0;
        field {
            desc = "Select a trigger event";
            sw = rw;
            hw = r;
//             reset_port_p = "reset_n_warm_ovrride";
        } EventType1[27:22] = 0x0;
        field {
            desc = "Select the bit position of custom action bus to be set when EAP trigger is met. External blocks can define and implement the specifc action for a given bit.";
            sw = rw;
            hw = r;
//             reset_port_p = "reset_n_warm_ovrride";
        } CustomAction0[31:28] = 0x0;
        field {
            desc = "Select the bit position of custom action bus to be set when EAP trigger is met. External blocks can define and implement the specifc action for a given bit.";
            sw = rw;
            hw = r;
//             reset_port_p = "reset_n_warm_ovrride";
        } CustomAction1[35:32] = 0x0;
        field {
            desc = "custom_action0 is valid only if custom_action0_enable is set";
            sw = rw;
            hw = r;
//             reset_port_p = "reset_n_warm_ovrride";
        } CustomAction0Enable[36:36] = 0x0;
        field {
            desc = "custom_action1 is valid only if custom_action1_enable is set";
            sw = rw;
            hw = r;
//             reset_port_p = "reset_n_warm_ovrride";
        } CustomAction1Enable[37:37] = 0x0;
        field {
            desc = "Select a trigger event";
            sw = rw;
            hw = r;
//             reset_port_p = "reset_n_warm_ovrride";
        } EventType2[43:38] = 0x0;
        field {
            desc = "User Defined Function with event type 0, 1, and 2 as arguments";
            sw = rw;
            hw = r;
//             reset_port_p = "reset_n_warm_ovrride";
        } Udf[51:44] = 0x0;
        field {
            desc = "Select an Action";
            sw = rw;
            hw = r;
//             reset_port_p = "reset_n_warm_ovrride";
        } Action2[57:52] = 0x0;
        field {
            desc = "Select an Action";
            sw = rw;
            hw = r;
//             reset_port_p = "reset_n_warm_ovrride";
        } Action3[63:58] = 0x0;
    } CDbgNode1Eap3 @ 0x3260;
    reg {
        desc = "CLA Action(s) are tied to events(s) using \"event-action pairing\" registers. One of he 8 EAPs (4 EAPs per Node).";
        regwidth = 0x40;
//         constraint_p = "";
        field {
            desc = "Select Destination Node";
            sw = rw;
            hw = r;
//             reset_port_p = "reset_n_warm_ovrride";
        } DestNode[1:0] = 0x0;
        field {
            desc = "Select an Action";
            sw = rw;
            hw = r;
//             reset_port_p = "reset_n_warm_ovrride";
        } Action0[7:2] = 0x0;
        field {
            desc = "Select an Action";
            sw = rw;
            hw = r;
//             reset_port_p = "reset_n_warm_ovrride";
        } Action1[13:8] = 0x0;
        field {
            desc = "Relation to be satisfied among events to activate the actions";
            sw = rw;
            hw = r;
//             reset_port_p = "reset_n_warm_ovrride";
        } LogicalOp[15:14] = 0x0;
        field {
            desc = "Select a trigger event";
            sw = rw;
            hw = r;
//             reset_port_p = "reset_n_warm_ovrride";
        } EventType0[21:16] = 0x0;
        field {
            desc = "Select a trigger event";
            sw = rw;
            hw = r;
//             reset_port_p = "reset_n_warm_ovrride";
        } EventType1[27:22] = 0x0;
        field {
            desc = "Select the bit position of custom action bus to be set when EAP trigger is met. External blocks can define and implement the specifc action for a given bit.";
            sw = rw;
            hw = r;
//             reset_port_p = "reset_n_warm_ovrride";
        } CustomAction0[31:28] = 0x0;
        field {
            desc = "Select the bit position of custom action bus to be set when EAP trigger is met. External blocks can define and implement the specifc action for a given bit.";
            sw = rw;
            hw = r;
//             reset_port_p = "reset_n_warm_ovrride";
        } CustomAction1[35:32] = 0x0;
        field {
            desc = "custom_action0 is valid only if custom_action0_enable is set";
            sw = rw;
            hw = r;
//             reset_port_p = "reset_n_warm_ovrride";
        } CustomAction0Enable[36:36] = 0x0;
        field {
            desc = "custom_action1 is valid only if custom_action1_enable is set";
            sw = rw;
            hw = r;
//             reset_port_p = "reset_n_warm_ovrride";
        } CustomAction1Enable[37:37] = 0x0;
        field {
            desc = "Select a trigger event";
            sw = rw;
            hw = r;
//             reset_port_p = "reset_n_warm_ovrride";
        } EventType2[43:38] = 0x0;
        field {
            desc = "User Defined Function with event type 0, 1, and 2 as arguments";
            sw = rw;
            hw = r;
//             reset_port_p = "reset_n_warm_ovrride";
        } Udf[51:44] = 0x0;
        field {
            desc = "Select an Action";
            sw = rw;
            hw = r;
//             reset_port_p = "reset_n_warm_ovrride";
        } Action2[57:52] = 0x0;
        field {
            desc = "Select an Action";
            sw = rw;
            hw = r;
//             reset_port_p = "reset_n_warm_ovrride";
        } Action3[63:58] = 0x0;
    } CDbgNode2Eap2 @ 0x3268;
    reg {
        desc = "CLA Action(s) are tied to events(s) using \"event-action pairing\" registers. One of he 8 EAPs (4 EAPs per Node).";
        regwidth = 0x40;
//         constraint_p = "";
        field {
            desc = "Select Destination Node";
            sw = rw;
            hw = r;
//             reset_port_p = "reset_n_warm_ovrride";
        } DestNode[1:0] = 0x0;
        field {
            desc = "Select an Action";
            sw = rw;
            hw = r;
//             reset_port_p = "reset_n_warm_ovrride";
        } Action0[7:2] = 0x0;
        field {
            desc = "Select an Action";
            sw = rw;
            hw = r;
//             reset_port_p = "reset_n_warm_ovrride";
        } Action1[13:8] = 0x0;
        field {
            desc = "Relation to be satisfied among events to activate the actions";
            sw = rw;
            hw = r;
//             reset_port_p = "reset_n_warm_ovrride";
        } LogicalOp[15:14] = 0x0;
        field {
            desc = "Select a trigger event";
            sw = rw;
            hw = r;
//             reset_port_p = "reset_n_warm_ovrride";
        } EventType0[21:16] = 0x0;
        field {
            desc = "Select a trigger event";
            sw = rw;
            hw = r;
//             reset_port_p = "reset_n_warm_ovrride";
        } EventType1[27:22] = 0x0;
        field {
            desc = "Select the bit position of custom action bus to be set when EAP trigger is met. External blocks can define and implement the specifc action for a given bit.";
            sw = rw;
            hw = r;
//             reset_port_p = "reset_n_warm_ovrride";
        } CustomAction0[31:28] = 0x0;
        field {
            desc = "Select the bit position of custom action bus to be set when EAP trigger is met. External blocks can define and implement the specifc action for a given bit.";
            sw = rw;
            hw = r;
//             reset_port_p = "reset_n_warm_ovrride";
        } CustomAction1[35:32] = 0x0;
        field {
            desc = "custom_action0 is valid only if custom_action0_enable is set";
            sw = rw;
            hw = r;
//             reset_port_p = "reset_n_warm_ovrride";
        } CustomAction0Enable[36:36] = 0x0;
        field {
            desc = "custom_action1 is valid only if custom_action1_enable is set";
            sw = rw;
            hw = r;
//             reset_port_p = "reset_n_warm_ovrride";
        } CustomAction1Enable[37:37] = 0x0;
        field {
            desc = "Select a trigger event";
            sw = rw;
            hw = r;
//             reset_port_p = "reset_n_warm_ovrride";
        } EventType2[43:38] = 0x0;
        field {
            desc = "User Defined Function with event type 0, 1, and 2 as arguments";
            sw = rw;
            hw = r;
//             reset_port_p = "reset_n_warm_ovrride";
        } Udf[51:44] = 0x0;
        field {
            desc = "Select an Action";
            sw = rw;
            hw = r;
//             reset_port_p = "reset_n_warm_ovrride";
        } Action2[57:52] = 0x0;
        field {
            desc = "Select an Action";
            sw = rw;
            hw = r;
//             reset_port_p = "reset_n_warm_ovrride";
        } Action3[63:58] = 0x0;
    } CDbgNode2Eap3 @ 0x3270;
    reg {
        desc = "CLA Action(s) are tied to events(s) using \"event-action pairing\" registers. One of he 8 EAPs (4 EAPs per Node).";
        regwidth = 0x40;
//         constraint_p = "";
        field {
            desc = "Select Destination Node";
            sw = rw;
            hw = r;
//             reset_port_p = "reset_n_warm_ovrride";
        } DestNode[1:0] = 0x0;
        field {
            desc = "Select an Action";
            sw = rw;
            hw = r;
//             reset_port_p = "reset_n_warm_ovrride";
        } Action0[7:2] = 0x0;
        field {
            desc = "Select an Action";
            sw = rw;
            hw = r;
//             reset_port_p = "reset_n_warm_ovrride";
        } Action1[13:8] = 0x0;
        field {
            desc = "Relation to be satisfied among events to activate the actions";
            sw = rw;
            hw = r;
//             reset_port_p = "reset_n_warm_ovrride";
        } LogicalOp[15:14] = 0x0;
        field {
            desc = "Select a trigger event";
            sw = rw;
            hw = r;
//             reset_port_p = "reset_n_warm_ovrride";
        } EventType0[21:16] = 0x0;
        field {
            desc = "Select a trigger event";
            sw = rw;
            hw = r;
//             reset_port_p = "reset_n_warm_ovrride";
        } EventType1[27:22] = 0x0;
        field {
            desc = "Select the bit position of custom action bus to be set when EAP trigger is met. External blocks can define and implement the specifc action for a given bit.";
            sw = rw;
            hw = r;
//             reset_port_p = "reset_n_warm_ovrride";
        } CustomAction0[31:28] = 0x0;
        field {
            desc = "Select the bit position of custom action bus to be set when EAP trigger is met. External blocks can define and implement the specifc action for a given bit.";
            sw = rw;
            hw = r;
//             reset_port_p = "reset_n_warm_ovrride";
        } CustomAction1[35:32] = 0x0;
        field {
            desc = "custom_action0 is valid only if custom_action0_enable is set";
            sw = rw;
            hw = r;
//             reset_port_p = "reset_n_warm_ovrride";
        } CustomAction0Enable[36:36] = 0x0;
        field {
            desc = "custom_action1 is valid only if custom_action1_enable is set";
            sw = rw;
            hw = r;
//             reset_port_p = "reset_n_warm_ovrride";
        } CustomAction1Enable[37:37] = 0x0;
        field {
            desc = "Select a trigger event";
            sw = rw;
            hw = r;
//             reset_port_p = "reset_n_warm_ovrride";
        } EventType2[43:38] = 0x0;
        field {
            desc = "User Defined Function with event type 0, 1, and 2 as arguments";
            sw = rw;
            hw = r;
//             reset_port_p = "reset_n_warm_ovrride";
        } Udf[51:44] = 0x0;
        field {
            desc = "Select an Action";
            sw = rw;
            hw = r;
//             reset_port_p = "reset_n_warm_ovrride";
        } Action2[57:52] = 0x0;
        field {
            desc = "Select an Action";
            sw = rw;
            hw = r;
//             reset_port_p = "reset_n_warm_ovrride";
        } Action3[63:58] = 0x0;
    } CDbgNode3Eap2 @ 0x3278;
    reg {
        desc = "CLA Action(s) are tied to events(s) using \"event-action pairing\" registers. One of he 8 EAPs (4 EAPs per Node).";
        regwidth = 0x40;
//         constraint_p = "";
        field {
            desc = "Select Destination Node";
            sw = rw;
            hw = r;
//             reset_port_p = "reset_n_warm_ovrride";
        } DestNode[1:0] = 0x0;
        field {
            desc = "Select an Action";
            sw = rw;
            hw = r;
//             reset_port_p = "reset_n_warm_ovrride";
        } Action0[7:2] = 0x0;
        field {
            desc = "Select an Action";
            sw = rw;
            hw = r;
//             reset_port_p = "reset_n_warm_ovrride";
        } Action1[13:8] = 0x0;
        field {
            desc = "Relation to be satisfied among events to activate the actions";
            sw = rw;
            hw = r;
//             reset_port_p = "reset_n_warm_ovrride";
        } LogicalOp[15:14] = 0x0;
        field {
            desc = "Select a trigger event";
            sw = rw;
            hw = r;
//             reset_port_p = "reset_n_warm_ovrride";
        } EventType0[21:16] = 0x0;
        field {
            desc = "Select a trigger event";
            sw = rw;
            hw = r;
//             reset_port_p = "reset_n_warm_ovrride";
        } EventType1[27:22] = 0x0;
        field {
            desc = "Select the bit position of custom action bus to be set when EAP trigger is met. External blocks can define and implement the specifc action for a given bit.";
            sw = rw;
            hw = r;
//             reset_port_p = "reset_n_warm_ovrride";
        } CustomAction0[31:28] = 0x0;
        field {
            desc = "Select the bit position of custom action bus to be set when EAP trigger is met. External blocks can define and implement the specifc action for a given bit.";
            sw = rw;
            hw = r;
//             reset_port_p = "reset_n_warm_ovrride";
        } CustomAction1[35:32] = 0x0;
        field {
            desc = "custom_action0 is valid only if custom_action0_enable is set";
            sw = rw;
            hw = r;
//             reset_port_p = "reset_n_warm_ovrride";
        } CustomAction0Enable[36:36] = 0x0;
        field {
            desc = "custom_action1 is valid only if custom_action1_enable is set";
            sw = rw;
            hw = r;
//             reset_port_p = "reset_n_warm_ovrride";
        } CustomAction1Enable[37:37] = 0x0;
        field {
            desc = "Select a trigger event";
            sw = rw;
            hw = r;
//             reset_port_p = "reset_n_warm_ovrride";
        } EventType2[43:38] = 0x0;
        field {
            desc = "User Defined Function with event type 0, 1, and 2 as arguments";
            sw = rw;
            hw = r;
//             reset_port_p = "reset_n_warm_ovrride";
        } Udf[51:44] = 0x0;
        field {
            desc = "Select an Action";
            sw = rw;
            hw = r;
//             reset_port_p = "reset_n_warm_ovrride";
        } Action2[57:52] = 0x0;
        field {
            desc = "Select an Action";
            sw = rw;
            hw = r;
//             reset_port_p = "reset_n_warm_ovrride";
        } Action3[63:58] = 0x0;
    } CDbgNode3Eap3 @ 0x3280;
    reg {
        desc = "debug Bus Value when Node0 Eap2 Trigger is met.";
        regwidth = 0x40;
//         constraint_p = "";
        field {
            sw = r;
            hw = w;
//             reset_port_p = "reset_n_warm_ovrride";
        } Value[63:0] = 0x0;
    } CDbgSignalSnapshotNode0Eap2 @ 0x3288;
    reg {
        desc = "debug Bus Value when Node0 Eap3 Trigger is met.";
        regwidth = 0x40;
//         constraint_p = "";
        field {
            sw = r;
            hw = w;
//             reset_port_p = "reset_n_warm_ovrride";
        } Value[63:0] = 0x0;
    } CDbgSignalSnapshotNode0Eap3 @ 0x3290;
    reg {
        desc = "debug Bus Value when Node1 Eap2 Trigger is met.";
        regwidth = 0x40;
//         constraint_p = "";
        field {
            sw = r;
            hw = w;
//             reset_port_p = "reset_n_warm_ovrride";
        } Value[63:0] = 0x0;
    } CDbgSignalSnapshotNode1Eap2 @ 0x3298;
    reg {
        desc = "debug Bus Value when Node1 Eap3 Trigger is met.";
        regwidth = 0x40;
//         constraint_p = "";
        field {
            sw = r;
            hw = w;
//             reset_port_p = "reset_n_warm_ovrride";
        } Value[63:0] = 0x0;
    } CDbgSignalSnapshotNode1Eap3 @ 0x32A0;
    reg {
        desc = "debug Bus Value when Node2 Eap2 Trigger is met.";
        regwidth = 0x40;
//         constraint_p = "";
        field {
            sw = r;
            hw = w;
//             reset_port_p = "reset_n_warm_ovrride";
        } Value[63:0] = 0x0;
    } CDbgSignalSnapshotNode2Eap2 @ 0x32A8;
    reg {
        desc = "debug Bus Value when Node2 Eap3 Trigger is met.";
        regwidth = 0x40;
//         constraint_p = "";
        field {
            sw = r;
            hw = w;
//             reset_port_p = "reset_n_warm_ovrride";
        } Value[63:0] = 0x0;
    } CDbgSignalSnapshotNode2Eap3 @ 0x32B0;
    reg {
        desc = "debug Bus Value when Node3 Eap2 Trigger is met.";
        regwidth = 0x40;
//         constraint_p = "";
        field {
            sw = r;
            hw = w;
//             reset_port_p = "reset_n_warm_ovrride";
        } Value[63:0] = 0x0;
    } CDbgSignalSnapshotNode3Eap2 @ 0x32B8;
    reg {
        desc = "debug Bus Value when Node3 Eap3 Trigger is met.";
        regwidth = 0x40;
//         constraint_p = "";
        field {
            sw = r;
            hw = w;
//             reset_port_p = "reset_n_warm_ovrride";
        } Value[63:0] = 0x0;
    } CDbgSignalSnapshotNode3Eap3 @ 0x32C0;
    reg {
        desc = "";
        regwidth = 0x40;
//         constraint_p = "";
        field {
            desc = "Dbg Mux Shifted signals Select Bits for Lane 0";
            sw = rw;
            hw = r;
//             reset_port_p = "reset_n_warm_ovrride";
        } Muxselseg0[1:0] = 0x0;
        field {
            desc = "Dbg Mux Shifted signals Select Bits for Lane 1";
            sw = rw;
            hw = r;
//             reset_port_p = "reset_n_warm_ovrride";
        } Muxselseg1[3:2] = 0x0;
        field {
            desc = "Dbg Mux Shifted signals Select Bits for Lane 2";
            sw = rw;
            hw = r;
//             reset_port_p = "reset_n_warm_ovrride";
        } Muxselseg2[5:4] = 0x0;
        field {
            desc = "Dbg Mux Shifted signals Select Bits for Lane 3";
            sw = rw;
            hw = r;
//             reset_port_p = "reset_n_warm_ovrride";
        } Muxselseg3[7:6] = 0x0;
        field {
            desc = "Dbg Mux Shifted signals Select Bits for Lane 4";
            sw = rw;
            hw = r;
//             reset_port_p = "reset_n_warm_ovrride";
        } Muxselseg4[9:8] = 0x0;
        field {
            desc = "Dbg Mux Shifted signals Select Bits for Lane 5";
            sw = rw;
            hw = r;
//             reset_port_p = "reset_n_warm_ovrride";
        } Muxselseg5[11:10] = 0x0;
        field {
            desc = "Dbg Mux Shifted signals Select Bits for Lane 6";
            sw = rw;
            hw = r;
//             reset_port_p = "reset_n_warm_ovrride";
        } Muxselseg6[13:12] = 0x0;
        field {
            desc = "Dbg Mux Shifted signals Select Bits for Lane 7";
            sw = rw;
            hw = r;
//             reset_port_p = "reset_n_warm_ovrride";
        } Muxselseg7[15:14] = 0x0;
        field {
            sw = rw;
            hw = r;
//             reset_port_p = "reset_n_warm_ovrride";
        } Rsvd[63:16] = 0x0;
    } CDbgSignalDelayMuxSel @ 0x32C8;
    reg {
        desc = "This value is loaded to the finegrain timestamp counter based on a cross trigger to sync the time value across the multiple cluster's CLA blocks";
        regwidth = 0x40;
//         constraint_p = "";
        field {
            sw = rw;
            hw = r;
//             reset_port_p = "reset_n_warm_ovrride";
        } Timestamp[62:0] = 0x0;
        field {
            sw = rw;
            hw = r;
//             reset_port_p = "reset_n_warm_ovrride";
        } Timesyncmodeenable[63:63] = 0x0;
    } CDbgClaTimestampsync @ 0x32D0;
    reg {
        desc = "This value determines the time stretched pulse duration for the cross trigger. 8 bits for each of the two triggers.";
        regwidth = 0x40;
//         constraint_p = "";
        field {
            sw = rw;
            hw = r;
//             reset_port_p = "reset_n_warm_ovrride";
        } Xtrigger0Stretch[7:0] = 0x0;
        field {
            sw = rw;
            hw = r;
//             reset_port_p = "reset_n_warm_ovrride";
        } Xtrigger1Stretch[15:8] = 0x0;
        field {
            sw = rw;
            hw = r;
//             reset_port_p = "reset_n_warm_ovrride";
        } Rsvd[63:16] = 0x0;
    } CDbgClaXtriggerTimestretch @ 0x32D8;
    reg {
        desc = "Scratchpad register for DV";
        regwidth = 0x40;

        field {
            sw = rw;
            hw = r;
        } Data[63:0] = 0xBFBFBFBFBFBFBFBF;
    } CrScratchpad @ 0x33F0;
    reg {
        desc = "Additional scratch register for DV and potential ECO usage";
        regwidth = 0x40;

        field {
            sw = rw;
            hw = r;
        } Data[63:0] = 0x0;
    } Scratch @ 0x33F8;

    reg {
        desc = "";
        regwidth = 0x20;

        field {
            sw = rw;
            hw = rw;
        } Trfunnelactive[0:0] = 0x0;
        field {
            sw = rw;
            hw = rw;
        } Trfunnelenable[1:1] = 0x0;
        field {
            sw = r;
            hw = rw;
        } Trfunnelempty[3:3] = 0x1;
    } Trfunnelcontrol @ 0x4000;
    reg {
        desc = "";
        regwidth = 0x20;

        field {
            sw = r;
            hw = r;
        } Trfunnelvermajor[3:0] = 0x1;
        field {
            desc = "e";
            sw = r;
            hw = r;
        } Trfunnelverminor[7:4] = 0x0;
        field {
            sw = r;
            hw = r;
        } Trfunnelcomptype[11:8] = 0x8;
    } Trfunnelimpl @ 0x4004;
    reg {
        desc = "";
        regwidth = 0x20;

        field {
            desc = "Bits 7:0 are reserved for N-trace srcs and 15:8 for Dst sources";
            sw = rw;
            hw = rw;
        } Trfunneldisinput[15:0] = 0x0;
    } Trfunneldisinput @ 0x4008;
    reg {
        desc = "";
        regwidth = 0x20;

        field {
            sw = rw;
            hw = rw;
        } Trramactive[0:0] = 0x0;
        field {
            sw = rw;
            hw = rw;
        } Trramenable[1:1] = 0x0;
        field {
            sw = r;
            hw = rw;
        } Trramempty[3:3] = 0x1;
        field {
            sw = rw;
            hw = rw;
        } Trrammode[4:4] = 0x0;
        field {
            sw = rw;
            hw = rw;
        } Trramstoponwrap[8:8] = 0x0;
    } Trramcontrol @ 0x5000;
    reg {
        desc = "";
        regwidth = 0x20;

        field {
            sw = r;
            hw = r;
        } Trramvermajor[3:0] = 0x1;
        field {
            sw = r;
            hw = r;
        } Trramverminor[7:4] = 0x0;
        field {
            sw = r;
            hw = r;
        } Trramcomptype[11:8] = 0x9;
        field {
            sw = r;
            hw = r;
        } Trramhassram[12:12] = 0x1;
        field {
            sw = r;
            hw = r;
        } Trramhassmem[13:13] = 0x1;
        field {
            sw = rw;
            hw = r;
        } Trramvendorframelength[27:24] = 0x1;
    } Trramimpl @ 0x5004;
    reg {
        desc = "";
        regwidth = 0x20;

        field {
            sw = r;
            hw = r;
        } Rsvd10[1:0] = 0x0;
        field {
            sw = rw;
            hw = w;
        } Trramstartlow[31:2] = 0x0;
    } Trramstartlow @ 0x5010;
    reg {
        desc = "";
        regwidth = 0x20;

        field {
            sw = rw;
            hw = rw;
        } Trramstarthigh[31:0] = 0x0;
    } Trramstarthigh @ 0x5014;
    reg {
        desc = "";
        regwidth = 0x20;

        field {
            sw = r;
            hw = r;
        } Rsvd10[1:0] = 0x0;
        field {
            sw = rw;
            hw = w;
        } Trramlimitlow[31:2] = 0x2000;
    } Trramlimitlow @ 0x5018;
    reg {
        desc = "";
        regwidth = 0x20;

        field {
            sw = rw;
            hw = rw;
        } Trramlimithigh[31:0] = 0x0;
    } Trramlimithigh @ 0x501C;
    reg {
        desc = "";
        regwidth = 0x20;

        field {
            sw = r;
            hw = rw;
        } Trramwrap[0:0] = 0x0;
        field {
            sw = rw;
            hw = rw;
        } Trramwplow[31:2] = 0x0;
    } Trramwplow @ 0x5020;
    reg {
        desc = "";
        regwidth = 0x20;

        field {
            sw = rw;
            hw = rw;
        } Trramwphigh[31:0] = 0x0;
    } Trramwphigh @ 0x5024;
    reg {
        desc = "";
        regwidth = 0x20;

        field {
            sw = r;
            hw = r;
        } Rsvd10[1:0] = 0x0;
        field {
            sw = rw;
            hw = w;
        } Trramrplow[31:2] = 0x0;
    } Trramrplow @ 0x5028;
    reg {
        desc = "";
        regwidth = 0x20;

        field {
            sw = rw;
            hw = rw;
        } Trramrphigh[31:0] = 0x0;
    } Trramrphigh @ 0x502C;
    reg {
        desc = "";
        regwidth = 0x20;

        field {
            sw = r;
            hw = rw;
        } Trramdata[31:0] = 0x0;
    } Trramdata @ 0x5040;
    reg {
        desc = "";
        regwidth = 0x20;

        field {
            sw = r;
            hw = r;
        } Rsvd10[1:0] = 0x0;
        field {
            sw = rw;
            hw = r;
        } Trcustomramsmemlimitlow[31:2] = 0x1000;
    } Trcustomramsmemlimitlow @ 0x5E00;
    reg {
        desc = "";
        regwidth = 0x20;

        field {
            sw = rw;
            hw = rw;
        } Trdstramactive[0:0] = 0x0;
        field {
            sw = rw;
            hw = rw;
        } Trdstramenable[1:1] = 0x0;
        field {
            sw = r;
            hw = rw;
        } Trdstramempty[3:3] = 0x1;
        field {
            sw = rw;
            hw = rw;
        } Trdstrammode[4:4] = 0x0;
        field {
            sw = rw;
            hw = rw;
        } Trdstramstoponwrap[8:8] = 0x0;
    } Trdstramcontrol @ 0x6000;
    reg {
        desc = "";
        regwidth = 0x20;

        field {
            sw = r;
            hw = r;
        } Trdstramvermajor[3:0] = 0x1;
        field {
            sw = r;
            hw = r;
        } Trdstramverminor[7:4] = 0x0;
        field {
            sw = r;
            hw = r;
        } Trdstramcomptype[11:8] = 0x9;
        field {
            sw = r;
            hw = r;
        } Trdstramhassram[12:12] = 0x1;
        field {
            sw = r;
            hw = r;
        } Trdstramhassmem[13:13] = 0x1;
        field {
            sw = rw;
            hw = r;
        } Trdstramvendorframelength[27:24] = 0x1;
    } Trdstramimpl @ 0x6004;
    reg {
        desc = "";
        regwidth = 0x20;

        field {
            sw = r;
            hw = r;
        } Rsvd10[1:0] = 0x0;
        field {
            sw = rw;
            hw = w;
        } Trdstramstartlow[31:2] = 0x0;
    } Trdstramstartlow @ 0x6010;
    reg {
        desc = "";
        regwidth = 0x20;

        field {
            sw = rw;
            hw = rw;
        } Trdstramstarthigh[31:0] = 0x0;
    } Trdstramstarthigh @ 0x6014;
    reg {
        desc = "";
        regwidth = 0x20;

        field {
            sw = r;
            hw = r;
        } Rsvd10[1:0] = 0x0;
        field {
            sw = rw;
            hw = w;
        } Trdstramlimitlow[31:2] = 0x0;
    } Trdstramlimitlow @ 0x6018;
    reg {
        desc = "";
        regwidth = 0x20;

        field {
            sw = rw;
            hw = rw;
        } Trdstramlimithigh[31:0] = 0x0;
    } Trdstramlimithigh @ 0x601C;
    reg {
        desc = "";
        regwidth = 0x20;

        field {
            sw = r;
            hw = rw;
        } Trdstramwrap[0:0] = 0x0;
        field {
            sw = rw;
            hw = rw;
        } Trdstramwplow[31:2] = 0x0;
    } Trdstramwplow @ 0x6020;
    reg {
        desc = "";
        regwidth = 0x20;

        field {
            sw = rw;
            hw = rw;
        } Trdstramwphigh[31:0] = 0x0;
    } Trdstramwphigh @ 0x6024;
    reg {
        desc = "";
        regwidth = 0x20;

        field {
            sw = r;
            hw = r;
        } Rsvd10[1:0] = 0x0;
        field {
            sw = rw;
            hw = w;
        } Trdstramrplow[31:2] = 0x0;
    } Trdstramrplow @ 0x6028;
    reg {
        desc = "";
        regwidth = 0x20;

        field {
            sw = rw;
            hw = rw;
        } Trdstramrphigh[31:0] = 0x0;
    } Trdstramrphigh @ 0x602C;
    reg {
        desc = "";
        regwidth = 0x20;

        field {
            sw = r;
            hw = rw;
        } Trdstramdata[31:0] = 0x0;
    } Trdstramdata @ 0x6040;
    reg {
        desc = "";
        regwidth = 0x20;



        field {
            desc = "1 bit / 4 ways (total 8 bit /32 ways possible) 1: enable 0: disabled";
            sw = rw;
            hw = r;




        } ScHarvestStrap[7:0] = 0x0;
        field {
            desc = "CLA and Trace enable";
            sw = rw;
            hw = r;




        } TraceEnable[8:8] = 0x0;
        field {
            desc = "Debug enable. 00 - No Debug  01 - Default (JTAG based debug)  10 - AXI based debug  11 - Support both enabled at same time. Same cycle collision causes error packet";
            sw = rw;
            hw = r;




        } DebugEnable[10:9] = 0x0;
        field {
            desc = "Reserved for future use";
            sw = rw;
            hw = r;




        } Rsvd1411[14:11] = 0x0;
        field {
            desc = "Lock bit";
            sw = rw;
            hw = r;




        } Lock[15:15] = 0x0;
        field {
            desc = "Physical Core0 availability";
            sw = rw;
            hw = r;




        } Core0Enable[16:16] = 0x0;
        field {
            desc = "Physical Core0 vid";
            sw = rw;
            hw = r;




        } Core0Vid[19:17] = 0x0;
        field {
            desc = "Physical Core1 availability";
            sw = rw;
            hw = r;




        } Core1Enable[20:20] = 0x0;
        field {
            desc = "Physical Core1 vid";
            sw = rw;
            hw = r;




        } Core1Vid[23:21] = 0x0;
        field {
            desc = "Physical Core2 availability";
            sw = rw;
            hw = r;




        } Core2Enable[24:24] = 0x0;
        field {
            desc = "Physical Core2 vid";
            sw = rw;
            hw = r;




        } Core2Vid[27:25] = 0x0;
        field {
            desc = "Physical Core3 availability";
            sw = rw;
            hw = r;




        } Core3Enable[28:28] = 0x0;
        field {
            desc = "Physical Core3 vid";
            sw = rw;
            hw = r;




        } Core3Vid[31:29] = 0x0;
    } TrClusterFuseCfgLow @ 0x7FF8;
    reg {
        desc = "";
        regwidth = 0x20;



        field {
            desc = "Physical Core4 availability";
            sw = rw;
            hw = r;




        } Core4Enable[0:0] = 0x0;
        field {
            desc = "Physical Core4 vid";
            sw = rw;
            hw = r;




        } Core4Vid[3:1] = 0x0;
        field {
            desc = "Physical Core5 availability";
            sw = rw;
            hw = r;




        } Core5Enable[4:4] = 0x0;
        field {
            desc = "Physical Core5 vid";
            sw = rw;
            hw = r;




        } Core5Vid[7:5] = 0x0;
        field {
            desc = "Physical Core6 availability";
            sw = rw;
            hw = r;




        } Core6Enable[8:8] = 0x0;
        field {
            desc = "Physical Core6 vid";
            sw = rw;
            hw = r;




        } Core6Vid[11:9] = 0x0;
        field {
            desc = "Physical core7 availability";
            sw = rw;
            hw = r;




        } Core7Enable[12:12] = 0x0;
        field {
            desc = "Physical core7 vid";
            sw = rw;
            hw = r;




        } Core7Vid[15:13] = 0x0;
        field {
            desc = "Reserved for future use";
            sw = rw;
            hw = r;




        } Rsvd3116[31:16] = 0x0;
    } TrClusterFuseCfgHi @ 0x7FFC;
    reg {
        desc = "Additional scratch register for DV and potential ECO usage";
        regwidth = 0x20;

        field {
            sw = rw;
            hw = r;
        } Data[31:0] = 0x0;
    } TrScratchLo @ 0x8FE8;
    reg {
        desc = "Additional scratch register for DV and potential ECO usage";
        regwidth = 0x20;

        field {
            sw = rw;
            hw = r;
        } Data[31:0] = 0x0;
    } TrScratchHi @ 0x8FEC;
    reg {
        desc = "Scratchpad register for DV";
        regwidth = 0x20;

        field {
            sw = rw;
            hw = r;
        } Data[31:0] = 0xEFEFEFEF;
    } TrScratchpadLo @ 0x8FF0;
    reg {
        desc = "Scratchpad register for DV";
        regwidth = 0x20;

        field {
            sw = rw;
            hw = r;
        } Data[31:0] = 0xEFEFEFEF;
    } TrScratchpadHi @ 0x8FF4;
};

/*
        THIS IS AN AUTOGENERATED ADDRESS MAP

        CDbgMuxSel        @ 0x198
        CDfdCsr           @ 0x1A0

        Timestamp         @ 0x200
        TimestampSync     @ 0x208
        TimestampConfig   @ 0x210

        Trdstcontrol             @ 0x1000
        Trdstimpl                @ 0x1004
        Trdstinstfeatures        @ 0x1008
        CDbgDebugTraceCfg        @ 0x11A0

        CDbgClaCounter0Cfg                 @ 0x3100
        CDbgClaCounter1Cfg                 @ 0x3108
        CDbgClaCounter2Cfg                 @ 0x3110
        CDbgClaCounter3Cfg                 @ 0x3118
        CDbgNode0Eap0                      @ 0x3120
        CDbgNode0Eap1                      @ 0x3128
        CDbgNode1Eap0                      @ 0x3130
        CDbgNode1Eap1                      @ 0x3138
        CDbgNode2Eap0                      @ 0x3140
        CDbgNode2Eap1                      @ 0x3148
        CDbgNode3Eap0                      @ 0x3150
        CDbgNode3Eap1                      @ 0x3158
        CDbgSignalMask0                    @ 0x3160
        CDbgSignalMatch0                   @ 0x3168
        CDbgSignalMask1                    @ 0x3170
        CDbgSignalMatch1                   @ 0x3178
        CDbgSignalEdgeDetectCfg            @ 0x3180
        CDbgEapStatus                      @ 0x3188
        CDbgClaCtrlStatus                  @ 0x3190
        CDbgRsvd0                          @ 0x3198
        CDbgRsvd1                          @ 0x31A0
        CDbgRsvd2                          @ 0x31A8
        CDbgTransitionMask                 @ 0x31B0
        CDbgTransitionFromValue            @ 0x31B8
        CDbgTransitionToValue              @ 0x31C0
        CDbgOnesCountMask                  @ 0x31C8
        CDbgOnesCountValue                 @ 0x31D0
        CDbgAnyChange                      @ 0x31D8
        CDbgSignalSnapshotNode0Eap0        @ 0x31E0
        CDbgSignalSnapshotNode0Eap1        @ 0x31E8
        CDbgSignalSnapshotNode1Eap0        @ 0x31F0
        CDbgSignalSnapshotNode1Eap1        @ 0x31F8
        CDbgSignalSnapshotNode2Eap0        @ 0x3200
        CDbgSignalSnapshotNode2Eap1        @ 0x3208
        CDbgSignalSnapshotNode3Eap0        @ 0x3210
        CDbgSignalSnapshotNode3Eap1        @ 0x3218
        CDbgClaTimeMatch                   @ 0x3220
        CDbgSignalMask2                    @ 0x3228
        CDbgSignalMatch2                   @ 0x3230
        CDbgSignalMask3                    @ 0x3238
        CDbgSignalMatch3                   @ 0x3240
        CDbgNode0Eap2                      @ 0x3248
        CDbgNode0Eap3                      @ 0x3250
        CDbgNode1Eap2                      @ 0x3258
        CDbgNode1Eap3                      @ 0x3260
        CDbgNode2Eap2                      @ 0x3268
        CDbgNode2Eap3                      @ 0x3270
        CDbgNode3Eap2                      @ 0x3278
        CDbgNode3Eap3                      @ 0x3280
        CDbgSignalSnapshotNode0Eap2        @ 0x3288
        CDbgSignalSnapshotNode0Eap3        @ 0x3290
        CDbgSignalSnapshotNode1Eap2        @ 0x3298
        CDbgSignalSnapshotNode1Eap3        @ 0x32A0
        CDbgSignalSnapshotNode2Eap2        @ 0x32A8
        CDbgSignalSnapshotNode2Eap3        @ 0x32B0
        CDbgSignalSnapshotNode3Eap2        @ 0x32B8
        CDbgSignalSnapshotNode3Eap3        @ 0x32C0
        CDbgSignalDelayMuxSel              @ 0x32C8
        CDbgClaTimestampsync               @ 0x32D0
        CDbgClaXtriggerTimestretch         @ 0x32D8
        CrScratchpad                       @ 0x33F0
        Scratch                            @ 0x33F8

        Trfunnelcontrol                @ 0x4000
        Trfunnelimpl                   @ 0x4004
        Trfunneldisinput               @ 0x4008
        Trramcontrol                   @ 0x5000
        Trramimpl                      @ 0x5004
        Trramstartlow                  @ 0x5010
        Trramstarthigh                 @ 0x5014
        Trramlimitlow                  @ 0x5018
        Trramlimithigh                 @ 0x501C
        Trramwplow                     @ 0x5020
        Trramwphigh                    @ 0x5024
        Trramrplow                     @ 0x5028
        Trramrphigh                    @ 0x502C
        Trramdata                      @ 0x5040
        Trcustomramsmemlimitlow        @ 0x5E00
        Trdstramcontrol                @ 0x6000
        Trdstramimpl                   @ 0x6004
        Trdstramstartlow               @ 0x6010
        Trdstramstarthigh              @ 0x6014
        Trdstramlimitlow               @ 0x6018
        Trdstramlimithigh              @ 0x601C
        Trdstramwplow                  @ 0x6020
        Trdstramwphigh                 @ 0x6024
        Trdstramrplow                  @ 0x6028
        Trdstramrphigh                 @ 0x602C
        Trdstramdata                   @ 0x6040
        TrClusterFuseCfgLow            @ 0x7FF8
        TrClusterFuseCfgHi             @ 0x7FFC
        TrScratchLo                    @ 0x8FE8
        TrScratchHi                    @ 0x8FEC
        TrScratchpadLo                 @ 0x8FF0
        TrScratchpadHi                 @ 0x8FF4
*/
