// SPDX-License-Identifier: Apache-2.0
// SPDX-FileCopyrightText: 2026 Tenstorrent USA, Inc.

// dst_sink MMR block, generated by tools/regs/dfd_yaml_rdl.py from
// rtl/mmr/spec/dst_sink_mmrs.yml. Do not edit; run `make ocah-regen-dfd-rdl`.
//
// Addresses are block-relative: the composite that instantiates this
// block places it at the offset mmrs.sv decodes.

`ifndef DFD_DST_SINK_RDL
`define DFD_DST_SINK_RDL

addrmap dfd_dst_sink {
    reg {
        regwidth = 32;

        field {
            sw = rw;
            hw = rw;
        } Trdstramactive[0:0] = 0x0;
        field {
            sw = rw;
            hw = rw;
        } Trdstramenable[1:1] = 0x0;
        field {
            sw = r;
            hw = w;
        } Trdstramempty[3:3] = 0x1;
        field {
            sw = rw;
            hw = rw;
        } Trdstrammode[4:4] = 0x0;
        field {
            sw = rw;
            hw = rw;
        } Trdstramstoponwrap[8:8] = 0x0;
    } Trdstramcontrol @ 0x0;
    reg {
        regwidth = 32;

        field {
            sw = r;
            hw = r;
        } Trdstramvermajor[3:0] = 0x1;
        field {
            sw = r;
            hw = r;
        } Trdstramverminor[7:4] = 0x0;
        field {
            sw = r;
            hw = r;
        } Trdstramcomptype[11:8] = 0x9;
        field {
            sw = r;
            hw = r;
        } Trdstramhassram[12:12] = 0x1;
        field {
            sw = r;
            hw = r;
        } Trdstramhassmem[13:13] = 0x1;
        field {
            sw = rw;
            hw = r;
        } Trdstramvendorframelength[27:24] = 0x1;
    } Trdstramimpl @ 0x4;
    reg {
        regwidth = 32;

        field {
            sw = r;
            hw = r;
        } Rsvd10[1:0] = 0x0;
        field {
            sw = rw;
            hw = rw;
        } Trdstramstartlow[31:2] = 0x0;
    } Trdstramstartlow @ 0x10;
    reg {
        regwidth = 32;

        field {
            sw = rw;
            hw = rw;
        } Trdstramstarthigh[31:0] = 0x0;
    } Trdstramstarthigh @ 0x14;
    reg {
        regwidth = 32;

        field {
            sw = r;
            hw = r;
        } Rsvd10[1:0] = 0x0;
        field {
            sw = rw;
            hw = rw;
        } Trdstramlimitlow[31:2] = 0x0;
    } Trdstramlimitlow @ 0x18;
    reg {
        regwidth = 32;

        field {
            sw = rw;
            hw = rw;
        } Trdstramlimithigh[31:0] = 0x0;
    } Trdstramlimithigh @ 0x1C;
    reg {
        regwidth = 32;

        field {
            sw = r;
            hw = w;
        } Trdstramwrap[0:0] = 0x0;
        field {
            sw = rw;
            hw = rw;
        } Trdstramwplow[31:2] = 0x0;
    } Trdstramwplow @ 0x20;
    reg {
        regwidth = 32;

        field {
            sw = r;
            hw = w;
        } Trdstramwphigh[31:0] = 0x0;
    } Trdstramwphigh @ 0x24;
    reg {
        regwidth = 32;

        field {
            sw = r;
            hw = r;
        } Rsvd10[1:0] = 0x0;
        field {
            sw = rw;
            hw = rw;
        } Trdstramrplow[31:2] = 0x0;
    } Trdstramrplow @ 0x28;
    reg {
        regwidth = 32;

        field {
            sw = rw;
            hw = rw;
        } Trdstramrphigh[31:0] = 0x0;
    } Trdstramrphigh @ 0x2C;
    reg {
        regwidth = 32;

        field {
            sw = r;
            hw = w;
        } Trdstramdata[31:0] = 0x0;
    } Trdstramdata @ 0x40;
    reg {
        desc = "Scratch register (low) for DV and potential ECO usage";
        regwidth = 32;

        field {
            sw = rw;
            hw = r;
        } Data[31:0] = 0x0;
    } ScratchLo @ 0xFF8;
    reg {
        desc = "Scratch register (high) for DV and potential ECO usage";
        regwidth = 32;

        field {
            sw = rw;
            hw = r;
        } Data[31:0] = 0x0;
    } ScratchHi @ 0xFFC;
};

`endif
