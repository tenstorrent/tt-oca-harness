// SPDX-License-Identifier: Apache-2.0
// SPDX-FileCopyrightText: 2026 Tenstorrent USA, Inc.

// ntr_sink MMR block, generated by tools/regs/dfd_yaml_rdl.py from
// rtl/mmr/spec/ntr_sink_mmrs.yml. Do not edit; run `make ocah-regen-dfd-rdl`.
//
// Addresses are block-relative: the composite that instantiates this
// block places it at the offset mmrs.sv decodes.

`ifndef DFD_NTR_SINK_RDL
`define DFD_NTR_SINK_RDL

addrmap dfd_ntr_sink {
    reg {
        regwidth = 32;

        field {
            sw = rw;
            hw = rw;
        } Trramactive[0:0] = 0x0;
        field {
            sw = rw;
            hw = rw;
        } Trramenable[1:1] = 0x0;
        field {
            sw = r;
            hw = w;
        } Trramempty[3:3] = 0x1;
        field {
            sw = rw;
            hw = rw;
        } Trrammode[4:4] = 0x0;
        field {
            sw = rw;
            hw = rw;
        } Trramstoponwrap[8:8] = 0x0;
    } Trramcontrol @ 0x0;
    reg {
        regwidth = 32;

        field {
            sw = r;
            hw = r;
        } Trramvermajor[3:0] = 0x1;
        field {
            sw = r;
            hw = r;
        } Trramverminor[7:4] = 0x0;
        field {
            sw = r;
            hw = r;
        } Trramcomptype[11:8] = 0x9;
        field {
            sw = r;
            hw = r;
        } Trramhassram[12:12] = 0x1;
        field {
            sw = r;
            hw = r;
        } Trramhassmem[13:13] = 0x1;
        field {
            sw = rw;
            hw = r;
        } Trramvendorframelength[27:24] = 0x1;
    } Trramimpl @ 0x4;
    reg {
        regwidth = 32;

        field {
            sw = r;
            hw = r;
        } Rsvd10[1:0] = 0x0;
        field {
            sw = rw;
            hw = rw;
        } Trramstartlow[31:2] = 0x0;
    } Trramstartlow @ 0x10;
    reg {
        regwidth = 32;

        field {
            sw = rw;
            hw = rw;
        } Trramstarthigh[31:0] = 0x0;
    } Trramstarthigh @ 0x14;
    reg {
        regwidth = 32;

        field {
            sw = r;
            hw = r;
        } Rsvd10[1:0] = 0x0;
        field {
            sw = rw;
            hw = rw;
        } Trramlimitlow[31:2] = 0x2000;
    } Trramlimitlow @ 0x18;
    reg {
        regwidth = 32;

        field {
            sw = rw;
            hw = rw;
        } Trramlimithigh[31:0] = 0x0;
    } Trramlimithigh @ 0x1C;
    reg {
        regwidth = 32;

        field {
            sw = r;
            hw = w;
        } Trramwrap[0:0] = 0x0;
        field {
            sw = rw;
            hw = rw;
        } Trramwplow[31:2] = 0x0;
    } Trramwplow @ 0x20;
    reg {
        regwidth = 32;

        field {
            sw = rw;
            hw = rw;
        } Trramwphigh[31:0] = 0x0;
    } Trramwphigh @ 0x24;
    reg {
        regwidth = 32;

        field {
            sw = r;
            hw = r;
        } Rsvd10[1:0] = 0x0;
        field {
            sw = rw;
            hw = rw;
        } Trramrplow[31:2] = 0x0;
    } Trramrplow @ 0x28;
    reg {
        regwidth = 32;

        field {
            sw = rw;
            hw = rw;
        } Trramrphigh[31:0] = 0x0;
    } Trramrphigh @ 0x2C;
    reg {
        regwidth = 32;

        field {
            sw = r;
            hw = w;
        } Trramdata[31:0] = 0x0;
    } Trramdata @ 0x40;
    reg {
        regwidth = 32;

        field {
            sw = r;
            hw = r;
        } Rsvd10[1:0] = 0x0;
        field {
            sw = rw;
            hw = r;
        } Trcustomramsmemlimitlow[31:2] = 0x0;
    } Trcustomramsmemlimitlow @ 0xE00;
    reg {
        desc = "Scratch register (low) for DV and potential ECO usage";
        regwidth = 32;

        field {
            sw = rw;
            hw = r;
        } Data[31:0] = 0x0;
    } ScratchLo @ 0xFF8;
    reg {
        desc = "Scratch register (high) for DV and potential ECO usage";
        regwidth = 32;

        field {
            sw = rw;
            hw = r;
        } Data[31:0] = 0x0;
    } ScratchHi @ 0xFFC;
};

`endif
