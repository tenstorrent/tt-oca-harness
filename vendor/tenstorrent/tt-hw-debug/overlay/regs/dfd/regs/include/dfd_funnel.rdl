// SPDX-License-Identifier: Apache-2.0
// SPDX-FileCopyrightText: 2026 Tenstorrent USA, Inc.

// funnel MMR block, generated by tools/regs/dfd_yaml_rdl.py from
// rtl/mmr/spec/funnel_mmrs.yml. Do not edit; run `make ocah-regen-dfd-rdl`.
//
// Addresses are block-relative: the composite that instantiates this
// block places it at the offset mmrs.sv decodes.

`ifndef DFD_FUNNEL_RDL
`define DFD_FUNNEL_RDL

addrmap dfd_funnel {
    reg {
        regwidth = 32;

        field {
            sw = rw;
            hw = rw;
        } Trfunnelactive[0:0] = 0x0;
        field {
            sw = rw;
            hw = rw;
        } Trfunnelenable[1:1] = 0x0;
        field {
            sw = r;
            hw = w;
        } Trfunnelempty[3:3] = 0x1;
    } Trfunnelcontrol @ 0x0;
    reg {
        regwidth = 32;

        field {
            sw = r;
            hw = r;
        } Trfunnelvermajor[3:0] = 0x1;
        field {
            sw = r;
            hw = r;
            desc = "e";
        } Trfunnelverminor[7:4] = 0x0;
        field {
            sw = r;
            hw = r;
        } Trfunnelcomptype[11:8] = 0x8;
    } Trfunnelimpl @ 0x4;
    reg {
        regwidth = 32;

        field {
            sw = rw;
            hw = rw;
            desc = "Bits 7:0 are reserved for N-trace srcs and 15:8 for Dst sources";
        } Trfunneldisinput[15:0] = 0x0;
    } Trfunneldisinput @ 0x8;
    reg {
        desc = "Scratch register (low) for DV and potential ECO usage";
        regwidth = 32;

        field {
            sw = rw;
            hw = r;
        } Data[31:0] = 0x0;
    } ScratchLo @ 0xFF8;
    reg {
        desc = "Scratch register (high) for DV and potential ECO usage";
        regwidth = 32;

        field {
            sw = rw;
            hw = r;
        } Data[31:0] = 0x0;
    } ScratchHi @ 0xFFC;
};

`endif
