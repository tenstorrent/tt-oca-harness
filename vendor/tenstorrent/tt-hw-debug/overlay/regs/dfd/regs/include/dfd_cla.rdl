// SPDX-License-Identifier: Apache-2.0
// SPDX-FileCopyrightText: 2026 Tenstorrent USA, Inc.

// cla MMR block, generated by tools/regs/dfd_yaml_rdl.py from
// rtl/mmr/spec/cla_mmrs.yml. Do not edit; run `make ocah-regen-dfd-rdl`.
//
// Addresses are block-relative: the composite that instantiates this
// block places it at the offset mmrs.sv decodes.

`ifndef DFD_CLA_RDL
`define DFD_CLA_RDL

addrmap dfd_cla {
    reg {
        desc = "Configure CLA counter0. One of the 4 counters used for counting cycles after a event match, and trigger a action on match.";
        regwidth = 64;

        field {
            sw = rw;
            hw = rw;
        } Counter[15:0] = 0x0;
        field {
            sw = rw;
            hw = r;
        } Target[31:16] = 0x0;
        field {
            sw = rw;
            hw = r;
            desc = "When Counter = {upper_target,target} reset to 0.  With this bit set, counter will provide a periodic tick w/ frequency of (target +1) if the action is set to Auto Incr. The periodic tick will continue till Stop Auto Incr or Clear Counter action.";
        } ResetOnTarget[32:32] = 0x0;
        field {
            sw = rw;
            hw = rw;
        } UpperCounter[47:33] = 0x0;
        field {
            sw = rw;
            hw = r;
        } UpperTarget[62:48] = 0x0;
        field {
            sw = rw;
            hw = r;
        } Rsvd[63:63] = 0x0;
    } CDbgClaCounter0Cfg @ 0x100;
    reg {
        desc = "Configure CLA counter1. One of the 4 counters used for counting cycles after a event match, and trigger a action on match.";
        regwidth = 64;

        field {
            sw = rw;
            hw = rw;
        } Counter[15:0] = 0x0;
        field {
            sw = rw;
            hw = r;
        } Target[31:16] = 0x0;
        field {
            sw = rw;
            hw = r;
            desc = "When Counter = {upper_targe,target}, reset to 0.  With this bit set, counter will provide a periodic tick w/ frequency of (target +1) if the action is set to Auto Incr. The periodic tick will continue till Stop Auto Incr or Clear Counter action.";
        } ResetOnTarget[32:32] = 0x0;
        field {
            sw = rw;
            hw = rw;
        } UpperCounter[47:33] = 0x0;
        field {
            sw = rw;
            hw = r;
        } UpperTarget[62:48] = 0x0;
        field {
            sw = rw;
            hw = r;
        } Rsvd[63:63] = 0x0;
    } CDbgClaCounter1Cfg @ 0x108;
    reg {
        desc = "Configure CLA counter2. One of the 4 counters used for counting cycles after a event match, and trigger a action on match.";
        regwidth = 64;

        field {
            sw = rw;
            hw = rw;
        } Counter[15:0] = 0x0;
        field {
            sw = rw;
            hw = r;
        } Target[31:16] = 0x0;
        field {
            sw = rw;
            hw = r;
            desc = "When Counter = {upper_target,target}, reset to 0.  With this bit set, counter will provide a periodic tick w/ frequency of (target +1) if the action is set to Auto Incr. The periodic tick will continue till Stop Auto Incr or Clear Counter action.";
        } ResetOnTarget[32:32] = 0x0;
        field {
            sw = rw;
            hw = rw;
        } UpperCounter[47:33] = 0x0;
        field {
            sw = rw;
            hw = r;
        } UpperTarget[62:48] = 0x0;
        field {
            sw = rw;
            hw = r;
        } Rsvd[63:63] = 0x0;
    } CDbgClaCounter2Cfg @ 0x110;
    reg {
        desc = "Configure CLA counter3. One of the 4 counters used for counting cycles after a event match, and trigger a action on match.";
        regwidth = 64;

        field {
            sw = rw;
            hw = rw;
        } Counter[15:0] = 0x0;
        field {
            sw = rw;
            hw = r;
        } Target[31:16] = 0x0;
        field {
            sw = rw;
            hw = r;
            desc = "When Counter = {upper_target,target}, reset to 0.  With this bit set, counter will provide a periodic tick w/ frequency of (target +1) if the action is set to Auto Incr. The periodic tick will continue till Stop Auto Incr or Clear Counter action.";
        } ResetOnTarget[32:32] = 0x0;
        field {
            sw = rw;
            hw = rw;
        } UpperCounter[47:33] = 0x0;
        field {
            sw = rw;
            hw = r;
        } UpperTarget[62:48] = 0x0;
        field {
            sw = rw;
            hw = r;
        } Rsvd[63:63] = 0x0;
    } CDbgClaCounter3Cfg @ 0x118;
    reg {
        desc = "CLA Action(s) are tied to events(s) using \"event-action pairing\" registers. One of he 8 EAPs (4 EAPs per Node).";
        regwidth = 64;

        field {
            sw = rw;
            hw = r;
            desc = "Select Destination Node";
        } DestNode[1:0] = 0x0;
        field {
            sw = rw;
            hw = r;
            desc = "Select an Action";
        } Action0[7:2] = 0x0;
        field {
            sw = rw;
            hw = r;
            desc = "Select an Action";
        } Action1[13:8] = 0x0;
        field {
            sw = rw;
            hw = r;
            desc = "Relation to be satisfied among events to activate the actions";
        } LogicalOp[15:14] = 0x0;
        field {
            sw = rw;
            hw = r;
            desc = "Select a trigger event";
        } EventType0[21:16] = 0x0;
        field {
            sw = rw;
            hw = r;
            desc = "Select a trigger event";
        } EventType1[27:22] = 0x0;
        field {
            sw = rw;
            hw = r;
            desc = "Select the bit position of custom action bus to be set when EAP trigger is met. External blocks can define and implement the specifc action for a given bit.";
        } CustomAction0[31:28] = 0x0;
        field {
            sw = rw;
            hw = r;
            desc = "Select the bit position of custom action bus to be set when EAP trigger is met. External blocks can define and implement the specifc action for a given bit.";
        } CustomAction1[35:32] = 0x0;
        field {
            sw = rw;
            hw = r;
            desc = "custom_action0 is valid only if custom_action0_enable is set";
        } CustomAction0Enable[36:36] = 0x0;
        field {
            sw = rw;
            hw = r;
            desc = "custom_action1 is valid only if custom_action1_enable is set";
        } CustomAction1Enable[37:37] = 0x0;
        field {
            sw = rw;
            hw = r;
            desc = "Select a trigger event";
        } EventType2[43:38] = 0x0;
        field {
            sw = rw;
            hw = r;
            desc = "User Defined Function with event type 0, 1, and 2 as arguments";
        } Udf[51:44] = 0x0;
        field {
            sw = rw;
            hw = r;
            desc = "Select an Action";
        } Action2[57:52] = 0x0;
        field {
            sw = rw;
            hw = r;
            desc = "Select an Action";
        } Action3[63:58] = 0x0;
    } CDbgNode0Eap0 @ 0x120;
    reg {
        desc = "CLA Action(s) are tied to events(s) using \"event-action pairing\" registers. One of he 8 EAPs (4 EAPs per Node).";
        regwidth = 64;

        field {
            sw = rw;
            hw = r;
            desc = "Select Destination Node";
        } DestNode[1:0] = 0x0;
        field {
            sw = rw;
            hw = r;
            desc = "Select an Action";
        } Action0[7:2] = 0x0;
        field {
            sw = rw;
            hw = r;
            desc = "Select an Action";
        } Action1[13:8] = 0x0;
        field {
            sw = rw;
            hw = r;
            desc = "Relation to be satisfied among events to activate the actions";
        } LogicalOp[15:14] = 0x0;
        field {
            sw = rw;
            hw = r;
            desc = "Select a trigger event";
        } EventType0[21:16] = 0x0;
        field {
            sw = rw;
            hw = r;
            desc = "Select a trigger event";
        } EventType1[27:22] = 0x0;
        field {
            sw = rw;
            hw = r;
            desc = "Select the bit position of custom action bus to be set when EAP trigger is met. External blocks can define and implement the specifc action for a given bit.";
        } CustomAction0[31:28] = 0x0;
        field {
            sw = rw;
            hw = r;
            desc = "Select the bit position of custom action bus to be set when EAP trigger is met. External blocks can define and implement the specifc action for a given bit.";
        } CustomAction1[35:32] = 0x0;
        field {
            sw = rw;
            hw = r;
            desc = "custom_action0 is valid only if custom_action0_enable is set";
        } CustomAction0Enable[36:36] = 0x0;
        field {
            sw = rw;
            hw = r;
            desc = "custom_action1 is valid only if custom_action1_enable is set";
        } CustomAction1Enable[37:37] = 0x0;
        field {
            sw = rw;
            hw = r;
            desc = "Select a trigger event";
        } EventType2[43:38] = 0x0;
        field {
            sw = rw;
            hw = r;
            desc = "User Defined Function with event type 0, 1, and 2 as arguments";
        } Udf[51:44] = 0x0;
        field {
            sw = rw;
            hw = r;
            desc = "Select an Action";
        } Action2[57:52] = 0x0;
        field {
            sw = rw;
            hw = r;
            desc = "Select an Action";
        } Action3[63:58] = 0x0;
    } CDbgNode0Eap1 @ 0x128;
    reg {
        desc = "CLA Action(s) are tied to events(s) using \"event-action pairing\" registers. One of he 8 EAPs (4 EAPs per Node).";
        regwidth = 64;

        field {
            sw = rw;
            hw = r;
            desc = "Select Destination Node";
        } DestNode[1:0] = 0x0;
        field {
            sw = rw;
            hw = r;
            desc = "Select an Action";
        } Action0[7:2] = 0x0;
        field {
            sw = rw;
            hw = r;
            desc = "Select an Action";
        } Action1[13:8] = 0x0;
        field {
            sw = rw;
            hw = r;
            desc = "Relation to be satisfied among events to activate the actions";
        } LogicalOp[15:14] = 0x0;
        field {
            sw = rw;
            hw = r;
            desc = "Select a trigger event";
        } EventType0[21:16] = 0x0;
        field {
            sw = rw;
            hw = r;
            desc = "Select a trigger event";
        } EventType1[27:22] = 0x0;
        field {
            sw = rw;
            hw = r;
            desc = "Select the bit position of custom action bus to be set when EAP trigger is met. External blocks can define and implement the specifc action for a given bit.";
        } CustomAction0[31:28] = 0x0;
        field {
            sw = rw;
            hw = r;
            desc = "Select the bit position of custom action bus to be set when EAP trigger is met. External blocks can define and implement the specifc action for a given bit.";
        } CustomAction1[35:32] = 0x0;
        field {
            sw = rw;
            hw = r;
            desc = "custom_action0 is valid only if custom_action0_enable is set";
        } CustomAction0Enable[36:36] = 0x0;
        field {
            sw = rw;
            hw = r;
            desc = "custom_action1 is valid only if custom_action1_enable is set";
        } CustomAction1Enable[37:37] = 0x0;
        field {
            sw = rw;
            hw = r;
            desc = "Select a trigger event";
        } EventType2[43:38] = 0x0;
        field {
            sw = rw;
            hw = r;
            desc = "User Defined Function with event type 0, 1, and 2 as arguments";
        } Udf[51:44] = 0x0;
        field {
            sw = rw;
            hw = r;
            desc = "Select an Action";
        } Action2[57:52] = 0x0;
        field {
            sw = rw;
            hw = r;
            desc = "Select an Action";
        } Action3[63:58] = 0x0;
    } CDbgNode1Eap0 @ 0x130;
    reg {
        desc = "CLA Action(s) are tied to events(s) using \"event-action pairing\" registers. One of he 8 EAPs (4 EAPs per Node).";
        regwidth = 64;

        field {
            sw = rw;
            hw = r;
            desc = "Select Destination Node";
        } DestNode[1:0] = 0x0;
        field {
            sw = rw;
            hw = r;
            desc = "Select an Action";
        } Action0[7:2] = 0x0;
        field {
            sw = rw;
            hw = r;
            desc = "Select an Action";
        } Action1[13:8] = 0x0;
        field {
            sw = rw;
            hw = r;
            desc = "Relation to be satisfied among events to activate the actions";
        } LogicalOp[15:14] = 0x0;
        field {
            sw = rw;
            hw = r;
            desc = "Select a trigger event";
        } EventType0[21:16] = 0x0;
        field {
            sw = rw;
            hw = r;
            desc = "Select a trigger event";
        } EventType1[27:22] = 0x0;
        field {
            sw = rw;
            hw = r;
            desc = "Select the bit position of custom action bus to be set when EAP trigger is met. External blocks can define and implement the specifc action for a given bit.";
        } CustomAction0[31:28] = 0x0;
        field {
            sw = rw;
            hw = r;
            desc = "Select the bit position of custom action bus to be set when EAP trigger is met. External blocks can define and implement the specifc action for a given bit.";
        } CustomAction1[35:32] = 0x0;
        field {
            sw = rw;
            hw = r;
            desc = "custom_action0 is valid only if custom_action0_enable is set";
        } CustomAction0Enable[36:36] = 0x0;
        field {
            sw = rw;
            hw = r;
            desc = "custom_action1 is valid only if custom_action1_enable is set";
        } CustomAction1Enable[37:37] = 0x0;
        field {
            sw = rw;
            hw = r;
            desc = "Select a trigger event";
        } EventType2[43:38] = 0x0;
        field {
            sw = rw;
            hw = r;
            desc = "User Defined Function with event type 0, 1, and 2 as arguments";
        } Udf[51:44] = 0x0;
        field {
            sw = rw;
            hw = r;
            desc = "Select an Action";
        } Action2[57:52] = 0x0;
        field {
            sw = rw;
            hw = r;
            desc = "Select an Action";
        } Action3[63:58] = 0x0;
    } CDbgNode1Eap1 @ 0x138;
    reg {
        desc = "CLA Action(s) are tied to events(s) using \"event-action pairing\" registers. One of he 8 EAPs (4 EAPs per Node).";
        regwidth = 64;

        field {
            sw = rw;
            hw = r;
            desc = "Select Destination Node";
        } DestNode[1:0] = 0x0;
        field {
            sw = rw;
            hw = r;
            desc = "Select an Action";
        } Action0[7:2] = 0x0;
        field {
            sw = rw;
            hw = r;
            desc = "Select an Action";
        } Action1[13:8] = 0x0;
        field {
            sw = rw;
            hw = r;
            desc = "Relation to be satisfied among events to activate the actions";
        } LogicalOp[15:14] = 0x0;
        field {
            sw = rw;
            hw = r;
            desc = "Select a trigger event";
        } EventType0[21:16] = 0x0;
        field {
            sw = rw;
            hw = r;
            desc = "Select a trigger event";
        } EventType1[27:22] = 0x0;
        field {
            sw = rw;
            hw = r;
            desc = "Select the bit position of custom action bus to be set when EAP trigger is met. External blocks can define and implement the specifc action for a given bit.";
        } CustomAction0[31:28] = 0x0;
        field {
            sw = rw;
            hw = r;
            desc = "Select the bit position of custom action bus to be set when EAP trigger is met. External blocks can define and implement the specifc action for a given bit.";
        } CustomAction1[35:32] = 0x0;
        field {
            sw = rw;
            hw = r;
            desc = "custom_action0 is valid only if custom_action0_enable is set";
        } CustomAction0Enable[36:36] = 0x0;
        field {
            sw = rw;
            hw = r;
            desc = "custom_action1 is valid only if custom_action1_enable is set";
        } CustomAction1Enable[37:37] = 0x0;
        field {
            sw = rw;
            hw = r;
            desc = "Select a trigger event";
        } EventType2[43:38] = 0x0;
        field {
            sw = rw;
            hw = r;
            desc = "User Defined Function with event type 0, 1, and 2 as arguments";
        } Udf[51:44] = 0x0;
        field {
            sw = rw;
            hw = r;
            desc = "Select an Action";
        } Action2[57:52] = 0x0;
        field {
            sw = rw;
            hw = r;
            desc = "Select an Action";
        } Action3[63:58] = 0x0;
    } CDbgNode2Eap0 @ 0x140;
    reg {
        desc = "CLA Action(s) are tied to events(s) using \"event-action pairing\" registers. One of he 8 EAPs (4 EAPs per Node).";
        regwidth = 64;

        field {
            sw = rw;
            hw = r;
            desc = "Select Destination Node";
        } DestNode[1:0] = 0x0;
        field {
            sw = rw;
            hw = r;
            desc = "Select an Action";
        } Action0[7:2] = 0x0;
        field {
            sw = rw;
            hw = r;
            desc = "Select an Action";
        } Action1[13:8] = 0x0;
        field {
            sw = rw;
            hw = r;
            desc = "Relation to be satisfied among events to activate the actions";
        } LogicalOp[15:14] = 0x0;
        field {
            sw = rw;
            hw = r;
            desc = "Select a trigger event";
        } EventType0[21:16] = 0x0;
        field {
            sw = rw;
            hw = r;
            desc = "Select a trigger event";
        } EventType1[27:22] = 0x0;
        field {
            sw = rw;
            hw = r;
            desc = "Select the bit position of custom action bus to be set when EAP trigger is met. External blocks can define and implement the specifc action for a given bit.";
        } CustomAction0[31:28] = 0x0;
        field {
            sw = rw;
            hw = r;
            desc = "Select the bit position of custom action bus to be set when EAP trigger is met. External blocks can define and implement the specifc action for a given bit.";
        } CustomAction1[35:32] = 0x0;
        field {
            sw = rw;
            hw = r;
            desc = "custom_action0 is valid only if custom_action0_enable is set";
        } CustomAction0Enable[36:36] = 0x0;
        field {
            sw = rw;
            hw = r;
            desc = "custom_action1 is valid only if custom_action1_enable is set";
        } CustomAction1Enable[37:37] = 0x0;
        field {
            sw = rw;
            hw = r;
            desc = "Select a trigger event";
        } EventType2[43:38] = 0x0;
        field {
            sw = rw;
            hw = r;
            desc = "User Defined Function with event type 0, 1, and 2 as arguments";
        } Udf[51:44] = 0x0;
        field {
            sw = rw;
            hw = r;
            desc = "Select an Action";
        } Action2[57:52] = 0x0;
        field {
            sw = rw;
            hw = r;
            desc = "Select an Action";
        } Action3[63:58] = 0x0;
    } CDbgNode2Eap1 @ 0x148;
    reg {
        desc = "CLA Action(s) are tied to events(s) using \"event-action pairing\" registers. One of he 8 EAPs (4 EAPs per Node).";
        regwidth = 64;

        field {
            sw = rw;
            hw = r;
            desc = "Select Destination Node";
        } DestNode[1:0] = 0x0;
        field {
            sw = rw;
            hw = r;
            desc = "Select an Action";
        } Action0[7:2] = 0x0;
        field {
            sw = rw;
            hw = r;
            desc = "Select an Action";
        } Action1[13:8] = 0x0;
        field {
            sw = rw;
            hw = r;
            desc = "Relation to be satisfied among events to activate the actions";
        } LogicalOp[15:14] = 0x0;
        field {
            sw = rw;
            hw = r;
            desc = "Select a trigger event";
        } EventType0[21:16] = 0x0;
        field {
            sw = rw;
            hw = r;
            desc = "Select a trigger event";
        } EventType1[27:22] = 0x0;
        field {
            sw = rw;
            hw = r;
            desc = "Select the bit position of custom action bus to be set when EAP trigger is met. External blocks can define and implement the specifc action for a given bit.";
        } CustomAction0[31:28] = 0x0;
        field {
            sw = rw;
            hw = r;
            desc = "Select the bit position of custom action bus to be set when EAP trigger is met. External blocks can define and implement the specifc action for a given bit.";
        } CustomAction1[35:32] = 0x0;
        field {
            sw = rw;
            hw = r;
            desc = "custom_action0 is valid only if custom_action0_enable is set";
        } CustomAction0Enable[36:36] = 0x0;
        field {
            sw = rw;
            hw = r;
            desc = "custom_action1 is valid only if custom_action1_enable is set";
        } CustomAction1Enable[37:37] = 0x0;
        field {
            sw = rw;
            hw = r;
            desc = "Select a trigger event";
        } EventType2[43:38] = 0x0;
        field {
            sw = rw;
            hw = r;
            desc = "User Defined Function with event type 0, 1, and 2 as arguments";
        } Udf[51:44] = 0x0;
        field {
            sw = rw;
            hw = r;
            desc = "Select an Action";
        } Action2[57:52] = 0x0;
        field {
            sw = rw;
            hw = r;
            desc = "Select an Action";
        } Action3[63:58] = 0x0;
    } CDbgNode3Eap0 @ 0x150;
    reg {
        desc = "CLA Action(s) are tied to events(s) using \"event-action pairing\" registers. One of he 8 EAPs (4 EAPs per Node).";
        regwidth = 64;

        field {
            sw = rw;
            hw = r;
            desc = "Select Destination Node";
        } DestNode[1:0] = 0x0;
        field {
            sw = rw;
            hw = r;
            desc = "Select an Action";
        } Action0[7:2] = 0x0;
        field {
            sw = rw;
            hw = r;
            desc = "Select an Action";
        } Action1[13:8] = 0x0;
        field {
            sw = rw;
            hw = r;
            desc = "Relation to be satisfied among events to activate the actions";
        } LogicalOp[15:14] = 0x0;
        field {
            sw = rw;
            hw = r;
            desc = "Select a trigger event";
        } EventType0[21:16] = 0x0;
        field {
            sw = rw;
            hw = r;
            desc = "Select a trigger event";
        } EventType1[27:22] = 0x0;
        field {
            sw = rw;
            hw = r;
            desc = "Select the bit position of custom action bus to be set when EAP trigger is met. External blocks can define and implement the specifc action for a given bit.";
        } CustomAction0[31:28] = 0x0;
        field {
            sw = rw;
            hw = r;
            desc = "Select the bit position of custom action bus to be set when EAP trigger is met. External blocks can define and implement the specifc action for a given bit.";
        } CustomAction1[35:32] = 0x0;
        field {
            sw = rw;
            hw = r;
            desc = "custom_action0 is valid only if custom_action0_enable is set";
        } CustomAction0Enable[36:36] = 0x0;
        field {
            sw = rw;
            hw = r;
            desc = "custom_action1 is valid only if custom_action1_enable is set";
        } CustomAction1Enable[37:37] = 0x0;
        field {
            sw = rw;
            hw = r;
            desc = "Select a trigger event";
        } EventType2[43:38] = 0x0;
        field {
            sw = rw;
            hw = r;
            desc = "User Defined Function with event type 0, 1, and 2 as arguments";
        } Udf[51:44] = 0x0;
        field {
            sw = rw;
            hw = r;
            desc = "Select an Action";
        } Action2[57:52] = 0x0;
        field {
            sw = rw;
            hw = r;
            desc = "Select an Action";
        } Action3[63:58] = 0x0;
    } CDbgNode3Eap1 @ 0x158;
    reg {
        desc = "Used to define debug bus match event. Match event (0x2) is triggered when debug_bus & mask = match.";
        regwidth = 64;

        field {
            sw = rw;
            hw = r;
            desc = "Mask to be applied to debug bus before match";
        } Value[63:0] = 0x0;
    } CDbgSignalMask0Lo @ 0x160;
    reg {
        desc = "Used to define debug bus match event. Match event (0x2) is triggered when debug_bus & mask = match.";
        regwidth = 64;

        field {
            sw = rw;
            hw = r;
            desc = "Value used for debug bus match.";
        } Value[63:0] = 0x0;
    } CDbgSignalMatch0Lo @ 0x168;
    reg {
        desc = "Used to define debug bus match event. Match event (0x4) is triggered when debug_bus & mask = match.";
        regwidth = 64;

        field {
            sw = rw;
            hw = r;
            desc = "Mask to be applied to debug bus before match";
        } Value[63:0] = 0x0;
    } CDbgSignalMask1Lo @ 0x170;
    reg {
        desc = "Used to define debug bus match event. Match event (0x4) is triggered when debug_bus & mask = match.";
        regwidth = 64;

        field {
            sw = rw;
            hw = r;
            desc = "Value used for debug bus match.";
        } Value[63:0] = 0x0;
    } CDbgSignalMatch1Lo @ 0x178;
    reg {
        desc = "Register to configure debug bus for edge triggers.";
        regwidth = 64;

        field {
            sw = rw;
            hw = r;
            desc = "Define which signal to select for edge detection.";
        } Signal0Select[6:0] = 0x0;
        field {
            sw = rw;
            hw = r;
            desc = "Defines which edge to detect for singal from signal0_select. 1: Pos edge, 0: Neg Edge";
        } PosEdgeSignal0[7:7] = 0x0;
        field {
            sw = rw;
            hw = r;
            desc = "Define which signal to select for edge detection.";
        } Signal1Select[14:8] = 0x0;
        field {
            sw = rw;
            hw = r;
            desc = "Defines which edge to detect for singal from signal1_select. 1: Pos edge, 0: Neg Edge";
        } PosEdgeSignal1[15:15] = 0x0;
    } CDbgSignalEdgeDetectCfg @ 0x180;
    reg {
        desc = "Register to indicate if an EAP was activated. There is one status bit per EAP in bits [15:0] (Node0Eap0..Node3Eap3, 4 EAPs per Node across 4 Nodes) and one write-to-clear bit per EAP in bits [47:32] (Node0Eap0W2C..Node3Eap3W2C); write the matching w2c bit to reset a status bit. The register is used by SW to know if an action was taken (ex: NMI ISR needs to know which of the EAP triggered the NMI)";
        regwidth = 64;

        field {
            sw = r;
            hw = w;
        } Node0Eap0[0:0] = 0x0;
        field {
            sw = r;
            hw = w;
        } Node0Eap1[1:1] = 0x0;
        field {
            sw = r;
            hw = w;
        } Node0Eap2[2:2] = 0x0;
        field {
            sw = r;
            hw = w;
        } Node0Eap3[3:3] = 0x0;
        field {
            sw = r;
            hw = w;
        } Node1Eap0[4:4] = 0x0;
        field {
            sw = r;
            hw = w;
        } Node1Eap1[5:5] = 0x0;
        field {
            sw = r;
            hw = w;
        } Node1Eap2[6:6] = 0x0;
        field {
            sw = r;
            hw = w;
        } Node1Eap3[7:7] = 0x0;
        field {
            sw = r;
            hw = w;
        } Node2Eap0[8:8] = 0x0;
        field {
            sw = r;
            hw = w;
        } Node2Eap1[9:9] = 0x0;
        field {
            sw = r;
            hw = w;
        } Node2Eap2[10:10] = 0x0;
        field {
            sw = r;
            hw = w;
        } Node2Eap3[11:11] = 0x0;
        field {
            sw = r;
            hw = w;
        } Node3Eap0[12:12] = 0x0;
        field {
            sw = r;
            hw = w;
        } Node3Eap1[13:13] = 0x0;
        field {
            sw = r;
            hw = w;
        } Node3Eap2[14:14] = 0x0;
        field {
            sw = r;
            hw = w;
        } Node3Eap3[15:15] = 0x0;
        field {
            sw = r;
            hw = w;
        } Rsvd3116[31:16] = 0x0;
        field {
            sw = rw;
            hw = rw;
        } Node0Eap0W2C[32:32] = 0x0;
        field {
            sw = rw;
            hw = rw;
        } Node0Eap1W2C[33:33] = 0x0;
        field {
            sw = rw;
            hw = rw;
        } Node0Eap2W2C[34:34] = 0x0;
        field {
            sw = rw;
            hw = rw;
        } Node0Eap3W2C[35:35] = 0x0;
        field {
            sw = rw;
            hw = rw;
        } Node1Eap0W2C[36:36] = 0x0;
        field {
            sw = rw;
            hw = rw;
        } Node1Eap1W2C[37:37] = 0x0;
        field {
            sw = rw;
            hw = rw;
        } Node1Eap2W2C[38:38] = 0x0;
        field {
            sw = rw;
            hw = rw;
        } Node1Eap3W2C[39:39] = 0x0;
        field {
            sw = rw;
            hw = rw;
        } Node2Eap0W2C[40:40] = 0x0;
        field {
            sw = rw;
            hw = rw;
        } Node2Eap1W2C[41:41] = 0x0;
        field {
            sw = rw;
            hw = rw;
        } Node2Eap2W2C[42:42] = 0x0;
        field {
            sw = rw;
            hw = rw;
        } Node2Eap3W2C[43:43] = 0x0;
        field {
            sw = rw;
            hw = rw;
        } Node3Eap0W2C[44:44] = 0x0;
        field {
            sw = rw;
            hw = rw;
        } Node3Eap1W2C[45:45] = 0x0;
        field {
            sw = rw;
            hw = rw;
        } Node3Eap2W2C[46:46] = 0x0;
        field {
            sw = rw;
            hw = rw;
        } Node3Eap3W2C[47:47] = 0x0;
    } CDbgEapStatus @ 0x188;
    reg {
        desc = "Ctrl/Status register to Enable EAP after EAP programming is complete, and read the current node.";
        regwidth = 64;

        field {
            sw = r;
            hw = w;
            desc = "Read the current node.";
        } CurrentNode[1:0] = 0x0;
        field {
            sw = rw;
            hw = r;
            desc = "Set Enable EAP to 1 after EAP programming is complete";
        } EnableEap[5:5] = 0x0;
        field {
            sw = rw;
            hw = r;
            desc = "Set this bit to 1 to enable the CLA functional clock; clear it to 0 to gate that clock (save pwr). The CLA register block runs on a clock whose functional enable is tied high, so this bit can still be written while the functional clock is gated";
        } EnableCla[6:6] = 0x0;
        field {
            sw = rw;
            hw = r;
            desc = "Creates a window in which we don’t forward the incoming Xtrigger and Clock_Halt signal";
        } ClaChainLoopDelay[13:7] = 0x36;
        field {
            sw = rw;
            hw = r;
            desc = "If this bit is set, clock halt action is not applied to global clocks";
        } DisableGlobalClockHalt[14:14] = 0x0;
        field {
            sw = rw;
            hw = r;
            desc = "If this bit is set, clock halt action is not applied to local clocks";
        } DisableLocalClockHalt[15:15] = 0x0;
        field {
            sw = rw;
            hw = r;
            desc = "reserved fields";
        } Rsvd6216[62:16] = 0x0;
        field {
            sw = rw;
            hw = r;
            desc = "If this bit is set, then CLA is locked and the enbale_cla is latched forever";
        } ClaLock[63:63] = 0x0;
    } CDbgClaCtrlStatus @ 0x190;
    reg {
        regwidth = 64;

        field {
            sw = rw;
            hw = r;
            desc = "Mode selection, 0: DBM off, 1: Normal debug mode, 2: DBM ID output mode, 3: Toggle Mode";
        } Dbmmode[1:0] = 0x0;
        field {
            sw = rw;
            hw = r;
            desc = "Unique DBM ID of the DBM instance";
        } Dbmid[7:2] = 0x0;
        field {
            sw = rw;
            hw = r;
            desc = "Fine Grain Time Enable. If this bit is set, the fine grain time is enabled.";
        } Finegraintime[8:8] = 0x0;
        field {
            sw = rw;
            hw = r;
        } Rsvd159[15:9] = 0x0;
        field {
            sw = rw;
            hw = r;
            desc = "Mux Select Bits for Lane 0. Split debug bus into 16 bit segments. Seg0 = debug bus [15:0], Seg1 = debug bus[31:16],.... If all bits are 0, Lane0 = Seg0, if bit[0] = 1, Lane0 = Seg4, if bit[1] =1, Lane0 = Seg5,...";
        } Muxselseg0[21:16] = 0x0;
        field {
            sw = rw;
            hw = r;
            desc = "Mux Select Bits for Lane 1. Split debug bus into 16 bit segments. Seg0 = debug bus [15:0], Seg1 = debug bus[31:16],.... If all bits are 0, Lane1= Seg1, if bit[0] = 1, Lane1 = Seg4, if bit[1] =1, Lane1 = Seg5,...";
        } Muxselseg1[27:22] = 0x0;
        field {
            sw = rw;
            hw = r;
            desc = "Mux Select Bits for Lane 2. Split debug bus into 16 bit segments. Seg0 = debug bus [15:0], Seg1 = debug bus[31:16],.... If all bits are 0, Lane2= Seg2, if bit[0] = 1, Lane2 = Seg4, if bit[1] =1, Lane2 = Seg5,...";
        } Muxselseg2[33:28] = 0x0;
        field {
            sw = rw;
            hw = r;
            desc = "Mux Select Bits for Lane 3. Split debug bus into 16 bit segments. Seg0 = debug bus [15:0], Seg1 = debug bus[31:16],.... If all bits are 0, Lane3= Seg3, if bit[0] = 1, Lane3 = Seg4, if bit[1] =1, Lane3 = Seg5,...";
        } Muxselseg3[39:34] = 0x0;
        field {
            sw = rw;
            hw = r;
        } Muxselseg4[45:40] = 0x0;
        field {
            sw = rw;
            hw = r;
        } Muxselseg5[51:46] = 0x0;
        field {
            sw = rw;
            hw = r;
        } Muxselseg6[57:52] = 0x0;
        field {
            sw = rw;
            hw = r;
        } Muxselseg7[63:58] = 0x0;
    } CDbgMuxSelLo @ 0x198;
    reg {
        desc = "Reserved Register that can be changed.";
        regwidth = 64;

        field {
            sw = rw;
            hw = r;
            desc = "Value of reserved register.";
        } Value[63:0] = 0x0;
    } CDbgRsvd1 @ 0x1A0;
    reg {
        desc = "Reserved Register that can be changed.";
        regwidth = 64;

        field {
            sw = rw;
            hw = r;
            desc = "Value of reserved register.";
        } Value[63:0] = 0x0;
    } CDbgRsvd2 @ 0x1A8;
    reg {
        desc = "3 registers to configure \"transition event\". This register is to select the signals of interest using a mask.";
        regwidth = 64;

        field {
            sw = rw;
            hw = r;
        } Value[63:0] = 0x0;
    } CDbgTransitionMaskLo @ 0x1B0;
    reg {
        desc = "3 registers to configure \"transition event\". The event is triggered on transition from Value A to Value B. This register specifies Value A.";
        regwidth = 64;

        field {
            sw = rw;
            hw = r;
        } Value[63:0] = 0x0;
    } CDbgTransitionFromValueLo @ 0x1B8;
    reg {
        desc = "3 registers to configure \"transition event\". The event is triggered on transition from Value A to Value B. This register specifies Value B.";
        regwidth = 64;

        field {
            sw = rw;
            hw = r;
        } Value[63:0] = 0x0;
    } CDbgTransitionToValueLo @ 0x1C0;
    reg {
        desc = "2 registers to configure \"ones count\" event. This register is to select the signals of interest using a mask.";
        regwidth = 64;

        field {
            sw = rw;
            hw = r;
        } Value[63:0] = 0x0;
    } CDbgOnesCountMaskLo @ 0x1C8;
    reg {
        desc = "2 registers to configure \"ones count\" event. Event triggered when the sum of the signals match the value specified in this register.";
        regwidth = 64;

        field {
            sw = rw;
            hw = r;
        } Value[63:0] = 0x0;
    } CDbgOnesCountValue @ 0x1D0;
    reg {
        desc = "Event triggered when a subset of debug signals change. The mask is used to select the subset of the debug signals.";
        regwidth = 64;

        field {
            sw = rw;
            hw = r;
        } Mask[63:0] = 0x0;
    } CDbgAnyChangeLo @ 0x1D8;
    reg {
        desc = "debug Bus Value when Node0 Eap0 Trigger is met.";
        regwidth = 64;

        field {
            sw = r;
            hw = w;
        } Value[63:0] = 0x0;
    } CDbgSignalSnapshotNode0Eap0Lo @ 0x1E0;
    reg {
        desc = "debug Bus Value when Node0 Eap1 Trigger is met.";
        regwidth = 64;

        field {
            sw = r;
            hw = w;
        } Value[63:0] = 0x0;
    } CDbgSignalSnapshotNode0Eap1Lo @ 0x1E8;
    reg {
        desc = "debug Bus Value when Node1 Eap0 Trigger is met.";
        regwidth = 64;

        field {
            sw = r;
            hw = w;
        } Value[63:0] = 0x0;
    } CDbgSignalSnapshotNode1Eap0Lo @ 0x1F0;
    reg {
        desc = "debug Bus Value when Node1 Eap0 Trigger is met.";
        regwidth = 64;

        field {
            sw = r;
            hw = w;
        } Value[63:0] = 0x0;
    } CDbgSignalSnapshotNode1Eap1Lo @ 0x1F8;
    reg {
        desc = "debug Bus Value when Node0 Eap0 Trigger is met.";
        regwidth = 64;

        field {
            sw = r;
            hw = w;
        } Value[63:0] = 0x0;
    } CDbgSignalSnapshotNode2Eap0Lo @ 0x200;
    reg {
        desc = "debug Bus Value when Node0 Eap1 Trigger is met.";
        regwidth = 64;

        field {
            sw = r;
            hw = w;
        } Value[63:0] = 0x0;
    } CDbgSignalSnapshotNode2Eap1Lo @ 0x208;
    reg {
        desc = "debug Bus Value when Node1 Eap0 Trigger is met.";
        regwidth = 64;

        field {
            sw = r;
            hw = w;
        } Value[63:0] = 0x0;
    } CDbgSignalSnapshotNode3Eap0Lo @ 0x210;
    reg {
        desc = "debug Bus Value when Node1 Eap0 Trigger is met.";
        regwidth = 64;

        field {
            sw = r;
            hw = w;
        } Value[63:0] = 0x0;
    } CDbgSignalSnapshotNode3Eap1Lo @ 0x218;
    reg {
        desc = "This value is compared (greater than or equal to the programmed value) against the internal time register value of the core, and is used to generate a time match event for CLA. Needs to be non zero for the time match event signal to trigger. The event will only trigger an action if the EAP programming is done. Requires writing 0 to this register to stop the match event.";
        regwidth = 64;

        field {
            sw = rw;
            hw = r;
        } TimeMatchVal[63:0] = 0x0;
    } CDbgClaTimeMatch @ 0x220;
    reg {
        desc = "Used to define debug bus match event. Match event (0x1C) is triggered when debug_bus & mask = match.";
        regwidth = 64;

        field {
            sw = rw;
            hw = r;
            desc = "Mask to be applied to debug bus before match";
        } Value[63:0] = 0x0;
    } CDbgSignalMask2Lo @ 0x228;
    reg {
        desc = "Used to define debug bus match event. Match event (0x1C) is triggered when debug_bus & mask = match.";
        regwidth = 64;

        field {
            sw = rw;
            hw = r;
            desc = "Value used for debug bus match.";
        } Value[63:0] = 0x0;
    } CDbgSignalMatch2Lo @ 0x230;
    reg {
        desc = "Used to define debug bus match event. Match event (0x1D) is triggered when debug_bus & mask = match.";
        regwidth = 64;

        field {
            sw = rw;
            hw = r;
            desc = "Mask to be applied to debug bus before match";
        } Value[63:0] = 0x0;
    } CDbgSignalMask3Lo @ 0x238;
    reg {
        desc = "Used to define debug bus match event. Match event (0x1D) is triggered when debug_bus & mask = match.";
        regwidth = 64;

        field {
            sw = rw;
            hw = r;
            desc = "Value used for debug bus match.";
        } Value[63:0] = 0x0;
    } CDbgSignalMatch3Lo @ 0x240;
    reg {
        desc = "CLA Action(s) are tied to events(s) using \"event-action pairing\" registers. One of he 8 EAPs (4 EAPs per Node).";
        regwidth = 64;

        field {
            sw = rw;
            hw = r;
            desc = "Select Destination Node";
        } DestNode[1:0] = 0x0;
        field {
            sw = rw;
            hw = r;
            desc = "Select an Action";
        } Action0[7:2] = 0x0;
        field {
            sw = rw;
            hw = r;
            desc = "Select an Action";
        } Action1[13:8] = 0x0;
        field {
            sw = rw;
            hw = r;
            desc = "Relation to be satisfied among events to activate the actions";
        } LogicalOp[15:14] = 0x0;
        field {
            sw = rw;
            hw = r;
            desc = "Select a trigger event";
        } EventType0[21:16] = 0x0;
        field {
            sw = rw;
            hw = r;
            desc = "Select a trigger event";
        } EventType1[27:22] = 0x0;
        field {
            sw = rw;
            hw = r;
            desc = "Select the bit position of custom action bus to be set when EAP trigger is met. External blocks can define and implement the specifc action for a given bit.";
        } CustomAction0[31:28] = 0x0;
        field {
            sw = rw;
            hw = r;
            desc = "Select the bit position of custom action bus to be set when EAP trigger is met. External blocks can define and implement the specifc action for a given bit.";
        } CustomAction1[35:32] = 0x0;
        field {
            sw = rw;
            hw = r;
            desc = "custom_action0 is valid only if custom_action0_enable is set";
        } CustomAction0Enable[36:36] = 0x0;
        field {
            sw = rw;
            hw = r;
            desc = "custom_action1 is valid only if custom_action1_enable is set";
        } CustomAction1Enable[37:37] = 0x0;
        field {
            sw = rw;
            hw = r;
            desc = "Select a trigger event";
        } EventType2[43:38] = 0x0;
        field {
            sw = rw;
            hw = r;
            desc = "User Defined Function with event type 0, 1, and 2 as arguments";
        } Udf[51:44] = 0x0;
        field {
            sw = rw;
            hw = r;
            desc = "Select an Action";
        } Action2[57:52] = 0x0;
        field {
            sw = rw;
            hw = r;
            desc = "Select an Action";
        } Action3[63:58] = 0x0;
    } CDbgNode0Eap2 @ 0x248;
    reg {
        desc = "CLA Action(s) are tied to events(s) using \"event-action pairing\" registers. One of he 8 EAPs (4 EAPs per Node).";
        regwidth = 64;

        field {
            sw = rw;
            hw = r;
            desc = "Select Destination Node";
        } DestNode[1:0] = 0x0;
        field {
            sw = rw;
            hw = r;
            desc = "Select an Action";
        } Action0[7:2] = 0x0;
        field {
            sw = rw;
            hw = r;
            desc = "Select an Action";
        } Action1[13:8] = 0x0;
        field {
            sw = rw;
            hw = r;
            desc = "Relation to be satisfied among events to activate the actions";
        } LogicalOp[15:14] = 0x0;
        field {
            sw = rw;
            hw = r;
            desc = "Select a trigger event";
        } EventType0[21:16] = 0x0;
        field {
            sw = rw;
            hw = r;
            desc = "Select a trigger event";
        } EventType1[27:22] = 0x0;
        field {
            sw = rw;
            hw = r;
            desc = "Select the bit position of custom action bus to be set when EAP trigger is met. External blocks can define and implement the specifc action for a given bit.";
        } CustomAction0[31:28] = 0x0;
        field {
            sw = rw;
            hw = r;
            desc = "Select the bit position of custom action bus to be set when EAP trigger is met. External blocks can define and implement the specifc action for a given bit.";
        } CustomAction1[35:32] = 0x0;
        field {
            sw = rw;
            hw = r;
            desc = "custom_action0 is valid only if custom_action0_enable is set";
        } CustomAction0Enable[36:36] = 0x0;
        field {
            sw = rw;
            hw = r;
            desc = "custom_action1 is valid only if custom_action1_enable is set";
        } CustomAction1Enable[37:37] = 0x0;
        field {
            sw = rw;
            hw = r;
            desc = "Select a trigger event";
        } EventType2[43:38] = 0x0;
        field {
            sw = rw;
            hw = r;
            desc = "User Defined Function with event type 0, 1, and 2 as arguments";
        } Udf[51:44] = 0x0;
        field {
            sw = rw;
            hw = r;
            desc = "Select an Action";
        } Action2[57:52] = 0x0;
        field {
            sw = rw;
            hw = r;
            desc = "Select an Action";
        } Action3[63:58] = 0x0;
    } CDbgNode0Eap3 @ 0x250;
    reg {
        desc = "CLA Action(s) are tied to events(s) using \"event-action pairing\" registers. One of he 8 EAPs (4 EAPs per Node).";
        regwidth = 64;

        field {
            sw = rw;
            hw = r;
            desc = "Select Destination Node";
        } DestNode[1:0] = 0x0;
        field {
            sw = rw;
            hw = r;
            desc = "Select an Action";
        } Action0[7:2] = 0x0;
        field {
            sw = rw;
            hw = r;
            desc = "Select an Action";
        } Action1[13:8] = 0x0;
        field {
            sw = rw;
            hw = r;
            desc = "Relation to be satisfied among events to activate the actions";
        } LogicalOp[15:14] = 0x0;
        field {
            sw = rw;
            hw = r;
            desc = "Select a trigger event";
        } EventType0[21:16] = 0x0;
        field {
            sw = rw;
            hw = r;
            desc = "Select a trigger event";
        } EventType1[27:22] = 0x0;
        field {
            sw = rw;
            hw = r;
            desc = "Select the bit position of custom action bus to be set when EAP trigger is met. External blocks can define and implement the specifc action for a given bit.";
        } CustomAction0[31:28] = 0x0;
        field {
            sw = rw;
            hw = r;
            desc = "Select the bit position of custom action bus to be set when EAP trigger is met. External blocks can define and implement the specifc action for a given bit.";
        } CustomAction1[35:32] = 0x0;
        field {
            sw = rw;
            hw = r;
            desc = "custom_action0 is valid only if custom_action0_enable is set";
        } CustomAction0Enable[36:36] = 0x0;
        field {
            sw = rw;
            hw = r;
            desc = "custom_action1 is valid only if custom_action1_enable is set";
        } CustomAction1Enable[37:37] = 0x0;
        field {
            sw = rw;
            hw = r;
            desc = "Select a trigger event";
        } EventType2[43:38] = 0x0;
        field {
            sw = rw;
            hw = r;
            desc = "User Defined Function with event type 0, 1, and 2 as arguments";
        } Udf[51:44] = 0x0;
        field {
            sw = rw;
            hw = r;
            desc = "Select an Action";
        } Action2[57:52] = 0x0;
        field {
            sw = rw;
            hw = r;
            desc = "Select an Action";
        } Action3[63:58] = 0x0;
    } CDbgNode1Eap2 @ 0x258;
    reg {
        desc = "CLA Action(s) are tied to events(s) using \"event-action pairing\" registers. One of he 8 EAPs (4 EAPs per Node).";
        regwidth = 64;

        field {
            sw = rw;
            hw = r;
            desc = "Select Destination Node";
        } DestNode[1:0] = 0x0;
        field {
            sw = rw;
            hw = r;
            desc = "Select an Action";
        } Action0[7:2] = 0x0;
        field {
            sw = rw;
            hw = r;
            desc = "Select an Action";
        } Action1[13:8] = 0x0;
        field {
            sw = rw;
            hw = r;
            desc = "Relation to be satisfied among events to activate the actions";
        } LogicalOp[15:14] = 0x0;
        field {
            sw = rw;
            hw = r;
            desc = "Select a trigger event";
        } EventType0[21:16] = 0x0;
        field {
            sw = rw;
            hw = r;
            desc = "Select a trigger event";
        } EventType1[27:22] = 0x0;
        field {
            sw = rw;
            hw = r;
            desc = "Select the bit position of custom action bus to be set when EAP trigger is met. External blocks can define and implement the specifc action for a given bit.";
        } CustomAction0[31:28] = 0x0;
        field {
            sw = rw;
            hw = r;
            desc = "Select the bit position of custom action bus to be set when EAP trigger is met. External blocks can define and implement the specifc action for a given bit.";
        } CustomAction1[35:32] = 0x0;
        field {
            sw = rw;
            hw = r;
            desc = "custom_action0 is valid only if custom_action0_enable is set";
        } CustomAction0Enable[36:36] = 0x0;
        field {
            sw = rw;
            hw = r;
            desc = "custom_action1 is valid only if custom_action1_enable is set";
        } CustomAction1Enable[37:37] = 0x0;
        field {
            sw = rw;
            hw = r;
            desc = "Select a trigger event";
        } EventType2[43:38] = 0x0;
        field {
            sw = rw;
            hw = r;
            desc = "User Defined Function with event type 0, 1, and 2 as arguments";
        } Udf[51:44] = 0x0;
        field {
            sw = rw;
            hw = r;
            desc = "Select an Action";
        } Action2[57:52] = 0x0;
        field {
            sw = rw;
            hw = r;
            desc = "Select an Action";
        } Action3[63:58] = 0x0;
    } CDbgNode1Eap3 @ 0x260;
    reg {
        desc = "CLA Action(s) are tied to events(s) using \"event-action pairing\" registers. One of he 8 EAPs (4 EAPs per Node).";
        regwidth = 64;

        field {
            sw = rw;
            hw = r;
            desc = "Select Destination Node";
        } DestNode[1:0] = 0x0;
        field {
            sw = rw;
            hw = r;
            desc = "Select an Action";
        } Action0[7:2] = 0x0;
        field {
            sw = rw;
            hw = r;
            desc = "Select an Action";
        } Action1[13:8] = 0x0;
        field {
            sw = rw;
            hw = r;
            desc = "Relation to be satisfied among events to activate the actions";
        } LogicalOp[15:14] = 0x0;
        field {
            sw = rw;
            hw = r;
            desc = "Select a trigger event";
        } EventType0[21:16] = 0x0;
        field {
            sw = rw;
            hw = r;
            desc = "Select a trigger event";
        } EventType1[27:22] = 0x0;
        field {
            sw = rw;
            hw = r;
            desc = "Select the bit position of custom action bus to be set when EAP trigger is met. External blocks can define and implement the specifc action for a given bit.";
        } CustomAction0[31:28] = 0x0;
        field {
            sw = rw;
            hw = r;
            desc = "Select the bit position of custom action bus to be set when EAP trigger is met. External blocks can define and implement the specifc action for a given bit.";
        } CustomAction1[35:32] = 0x0;
        field {
            sw = rw;
            hw = r;
            desc = "custom_action0 is valid only if custom_action0_enable is set";
        } CustomAction0Enable[36:36] = 0x0;
        field {
            sw = rw;
            hw = r;
            desc = "custom_action1 is valid only if custom_action1_enable is set";
        } CustomAction1Enable[37:37] = 0x0;
        field {
            sw = rw;
            hw = r;
            desc = "Select a trigger event";
        } EventType2[43:38] = 0x0;
        field {
            sw = rw;
            hw = r;
            desc = "User Defined Function with event type 0, 1, and 2 as arguments";
        } Udf[51:44] = 0x0;
        field {
            sw = rw;
            hw = r;
            desc = "Select an Action";
        } Action2[57:52] = 0x0;
        field {
            sw = rw;
            hw = r;
            desc = "Select an Action";
        } Action3[63:58] = 0x0;
    } CDbgNode2Eap2 @ 0x268;
    reg {
        desc = "CLA Action(s) are tied to events(s) using \"event-action pairing\" registers. One of he 8 EAPs (4 EAPs per Node).";
        regwidth = 64;

        field {
            sw = rw;
            hw = r;
            desc = "Select Destination Node";
        } DestNode[1:0] = 0x0;
        field {
            sw = rw;
            hw = r;
            desc = "Select an Action";
        } Action0[7:2] = 0x0;
        field {
            sw = rw;
            hw = r;
            desc = "Select an Action";
        } Action1[13:8] = 0x0;
        field {
            sw = rw;
            hw = r;
            desc = "Relation to be satisfied among events to activate the actions";
        } LogicalOp[15:14] = 0x0;
        field {
            sw = rw;
            hw = r;
            desc = "Select a trigger event";
        } EventType0[21:16] = 0x0;
        field {
            sw = rw;
            hw = r;
            desc = "Select a trigger event";
        } EventType1[27:22] = 0x0;
        field {
            sw = rw;
            hw = r;
            desc = "Select the bit position of custom action bus to be set when EAP trigger is met. External blocks can define and implement the specifc action for a given bit.";
        } CustomAction0[31:28] = 0x0;
        field {
            sw = rw;
            hw = r;
            desc = "Select the bit position of custom action bus to be set when EAP trigger is met. External blocks can define and implement the specifc action for a given bit.";
        } CustomAction1[35:32] = 0x0;
        field {
            sw = rw;
            hw = r;
            desc = "custom_action0 is valid only if custom_action0_enable is set";
        } CustomAction0Enable[36:36] = 0x0;
        field {
            sw = rw;
            hw = r;
            desc = "custom_action1 is valid only if custom_action1_enable is set";
        } CustomAction1Enable[37:37] = 0x0;
        field {
            sw = rw;
            hw = r;
            desc = "Select a trigger event";
        } EventType2[43:38] = 0x0;
        field {
            sw = rw;
            hw = r;
            desc = "User Defined Function with event type 0, 1, and 2 as arguments";
        } Udf[51:44] = 0x0;
        field {
            sw = rw;
            hw = r;
            desc = "Select an Action";
        } Action2[57:52] = 0x0;
        field {
            sw = rw;
            hw = r;
            desc = "Select an Action";
        } Action3[63:58] = 0x0;
    } CDbgNode2Eap3 @ 0x270;
    reg {
        desc = "CLA Action(s) are tied to events(s) using \"event-action pairing\" registers. One of he 8 EAPs (4 EAPs per Node).";
        regwidth = 64;

        field {
            sw = rw;
            hw = r;
            desc = "Select Destination Node";
        } DestNode[1:0] = 0x0;
        field {
            sw = rw;
            hw = r;
            desc = "Select an Action";
        } Action0[7:2] = 0x0;
        field {
            sw = rw;
            hw = r;
            desc = "Select an Action";
        } Action1[13:8] = 0x0;
        field {
            sw = rw;
            hw = r;
            desc = "Relation to be satisfied among events to activate the actions";
        } LogicalOp[15:14] = 0x0;
        field {
            sw = rw;
            hw = r;
            desc = "Select a trigger event";
        } EventType0[21:16] = 0x0;
        field {
            sw = rw;
            hw = r;
            desc = "Select a trigger event";
        } EventType1[27:22] = 0x0;
        field {
            sw = rw;
            hw = r;
            desc = "Select the bit position of custom action bus to be set when EAP trigger is met. External blocks can define and implement the specifc action for a given bit.";
        } CustomAction0[31:28] = 0x0;
        field {
            sw = rw;
            hw = r;
            desc = "Select the bit position of custom action bus to be set when EAP trigger is met. External blocks can define and implement the specifc action for a given bit.";
        } CustomAction1[35:32] = 0x0;
        field {
            sw = rw;
            hw = r;
            desc = "custom_action0 is valid only if custom_action0_enable is set";
        } CustomAction0Enable[36:36] = 0x0;
        field {
            sw = rw;
            hw = r;
            desc = "custom_action1 is valid only if custom_action1_enable is set";
        } CustomAction1Enable[37:37] = 0x0;
        field {
            sw = rw;
            hw = r;
            desc = "Select a trigger event";
        } EventType2[43:38] = 0x0;
        field {
            sw = rw;
            hw = r;
            desc = "User Defined Function with event type 0, 1, and 2 as arguments";
        } Udf[51:44] = 0x0;
        field {
            sw = rw;
            hw = r;
            desc = "Select an Action";
        } Action2[57:52] = 0x0;
        field {
            sw = rw;
            hw = r;
            desc = "Select an Action";
        } Action3[63:58] = 0x0;
    } CDbgNode3Eap2 @ 0x278;
    reg {
        desc = "CLA Action(s) are tied to events(s) using \"event-action pairing\" registers. One of he 8 EAPs (4 EAPs per Node).";
        regwidth = 64;

        field {
            sw = rw;
            hw = r;
            desc = "Select Destination Node";
        } DestNode[1:0] = 0x0;
        field {
            sw = rw;
            hw = r;
            desc = "Select an Action";
        } Action0[7:2] = 0x0;
        field {
            sw = rw;
            hw = r;
            desc = "Select an Action";
        } Action1[13:8] = 0x0;
        field {
            sw = rw;
            hw = r;
            desc = "Relation to be satisfied among events to activate the actions";
        } LogicalOp[15:14] = 0x0;
        field {
            sw = rw;
            hw = r;
            desc = "Select a trigger event";
        } EventType0[21:16] = 0x0;
        field {
            sw = rw;
            hw = r;
            desc = "Select a trigger event";
        } EventType1[27:22] = 0x0;
        field {
            sw = rw;
            hw = r;
            desc = "Select the bit position of custom action bus to be set when EAP trigger is met. External blocks can define and implement the specifc action for a given bit.";
        } CustomAction0[31:28] = 0x0;
        field {
            sw = rw;
            hw = r;
            desc = "Select the bit position of custom action bus to be set when EAP trigger is met. External blocks can define and implement the specifc action for a given bit.";
        } CustomAction1[35:32] = 0x0;
        field {
            sw = rw;
            hw = r;
            desc = "custom_action0 is valid only if custom_action0_enable is set";
        } CustomAction0Enable[36:36] = 0x0;
        field {
            sw = rw;
            hw = r;
            desc = "custom_action1 is valid only if custom_action1_enable is set";
        } CustomAction1Enable[37:37] = 0x0;
        field {
            sw = rw;
            hw = r;
            desc = "Select a trigger event";
        } EventType2[43:38] = 0x0;
        field {
            sw = rw;
            hw = r;
            desc = "User Defined Function with event type 0, 1, and 2 as arguments";
        } Udf[51:44] = 0x0;
        field {
            sw = rw;
            hw = r;
            desc = "Select an Action";
        } Action2[57:52] = 0x0;
        field {
            sw = rw;
            hw = r;
            desc = "Select an Action";
        } Action3[63:58] = 0x0;
    } CDbgNode3Eap3 @ 0x280;
    reg {
        desc = "debug Bus Value when Node0 Eap2 Trigger is met.";
        regwidth = 64;

        field {
            sw = r;
            hw = w;
        } Value[63:0] = 0x0;
    } CDbgSignalSnapshotNode0Eap2Lo @ 0x288;
    reg {
        desc = "debug Bus Value when Node0 Eap3 Trigger is met.";
        regwidth = 64;

        field {
            sw = r;
            hw = w;
        } Value[63:0] = 0x0;
    } CDbgSignalSnapshotNode0Eap3Lo @ 0x290;
    reg {
        desc = "debug Bus Value when Node1 Eap2 Trigger is met.";
        regwidth = 64;

        field {
            sw = r;
            hw = w;
        } Value[63:0] = 0x0;
    } CDbgSignalSnapshotNode1Eap2Lo @ 0x298;
    reg {
        desc = "debug Bus Value when Node1 Eap3 Trigger is met.";
        regwidth = 64;

        field {
            sw = r;
            hw = w;
        } Value[63:0] = 0x0;
    } CDbgSignalSnapshotNode1Eap3Lo @ 0x2A0;
    reg {
        desc = "debug Bus Value when Node2 Eap2 Trigger is met.";
        regwidth = 64;

        field {
            sw = r;
            hw = w;
        } Value[63:0] = 0x0;
    } CDbgSignalSnapshotNode2Eap2Lo @ 0x2A8;
    reg {
        desc = "debug Bus Value when Node2 Eap3 Trigger is met.";
        regwidth = 64;

        field {
            sw = r;
            hw = w;
        } Value[63:0] = 0x0;
    } CDbgSignalSnapshotNode2Eap3Lo @ 0x2B0;
    reg {
        desc = "debug Bus Value when Node3 Eap2 Trigger is met.";
        regwidth = 64;

        field {
            sw = r;
            hw = w;
        } Value[63:0] = 0x0;
    } CDbgSignalSnapshotNode3Eap2Lo @ 0x2B8;
    reg {
        desc = "debug Bus Value when Node3 Eap3 Trigger is met.";
        regwidth = 64;

        field {
            sw = r;
            hw = w;
        } Value[63:0] = 0x0;
    } CDbgSignalSnapshotNode3Eap3Lo @ 0x2C0;
    reg {
        regwidth = 64;

        field {
            sw = rw;
            hw = r;
            desc = "Dbg Mux Shifted signals Select Bits for Lane 0";
        } Muxselseg0[1:0] = 0x0;
        field {
            sw = rw;
            hw = r;
            desc = "Dbg Mux Shifted signals Select Bits for Lane 1";
        } Muxselseg1[3:2] = 0x0;
        field {
            sw = rw;
            hw = r;
            desc = "Dbg Mux Shifted signals Select Bits for Lane 2";
        } Muxselseg2[5:4] = 0x0;
        field {
            sw = rw;
            hw = r;
            desc = "Dbg Mux Shifted signals Select Bits for Lane 3";
        } Muxselseg3[7:6] = 0x0;
        field {
            sw = rw;
            hw = r;
            desc = "Dbg Mux Shifted signals Select Bits for Lane 4";
        } Muxselseg4[9:8] = 0x0;
        field {
            sw = rw;
            hw = r;
            desc = "Dbg Mux Shifted signals Select Bits for Lane 5";
        } Muxselseg5[11:10] = 0x0;
        field {
            sw = rw;
            hw = r;
            desc = "Dbg Mux Shifted signals Select Bits for Lane 6";
        } Muxselseg6[13:12] = 0x0;
        field {
            sw = rw;
            hw = r;
            desc = "Dbg Mux Shifted signals Select Bits for Lane 7";
        } Muxselseg7[15:14] = 0x0;
        field {
            sw = rw;
            hw = r;
            desc = "Dbg Mux Shifted signals Select Bits for Lane 0";
        } Muxselseg8[17:16] = 0x0;
        field {
            sw = rw;
            hw = r;
            desc = "Dbg Mux Shifted signals Select Bits for Lane 0";
        } Muxselseg9[19:18] = 0x0;
        field {
            sw = rw;
            hw = r;
            desc = "Dbg Mux Shifted signals Select Bits for Lane 0";
        } Muxselseg10[21:20] = 0x0;
        field {
            sw = rw;
            hw = r;
            desc = "Dbg Mux Shifted signals Select Bits for Lane 0";
        } Muxselseg11[23:22] = 0x0;
        field {
            sw = rw;
            hw = r;
            desc = "Dbg Mux Shifted signals Select Bits for Lane 0";
        } Muxselseg12[25:24] = 0x0;
        field {
            sw = rw;
            hw = r;
            desc = "Dbg Mux Shifted signals Select Bits for Lane 0";
        } Muxselseg13[27:26] = 0x0;
        field {
            sw = rw;
            hw = r;
            desc = "Dbg Mux Shifted signals Select Bits for Lane 0";
        } Muxselseg14[29:28] = 0x0;
        field {
            sw = rw;
            hw = r;
            desc = "Dbg Mux Shifted signals Select Bits for Lane 0";
        } Muxselseg15[31:30] = 0x0;
        field {
            sw = rw;
            hw = r;
        } Rsvd[63:32] = 0x0;
    } CDbgSignalDelayMuxSel @ 0x2C8;
    reg {
        desc = "This value determines the time stretched pulse duration for the cross trigger. 8 bits for each of the two triggers.";
        regwidth = 64;

        field {
            sw = rw;
            hw = r;
        } Xtrigger0Stretch[7:0] = 0x0;
        field {
            sw = rw;
            hw = r;
        } Xtrigger1Stretch[15:8] = 0x0;
        field {
            sw = rw;
            hw = r;
        } Rsvd[63:16] = 0x0;
    } CDbgClaXtriggerTimestretch @ 0x2D8;
    reg {
        desc = "64-bit timestamp counter. Increments on time_tick. Can be written directly or loaded from timestamp_sync on xtrigger when resync is enabled.";
        regwidth = 64;

        field {
            sw = rw;
            hw = rw;
            desc = "Current timestamp value (lower 8 bits)";
        } TimestampLower[7:0] = 0x0;
        field {
            sw = rw;
            hw = rw;
            desc = "Current timestamp value (upper 56 bits)";
        } TimestampUpper[63:8] = 0x0;
    } CDbgClaTimestamp @ 0x2F0;
    reg {
        desc = "Timestamp sync value. This value is loaded into the timestamp register on xtrigger posedge when resync bit is enabled.";
        regwidth = 64;

        field {
            sw = rw;
            hw = r;
            desc = "Sync value to load into timestamp";
        } TimestampSync[63:0] = 0x0;
    } CDbgClaTimestampSync @ 0x2F8;
    reg {
        desc = "Timestamp configuration register. Controls resync behavior and debug marker.";
        regwidth = 64;

        field {
            sw = rw;
            hw = rw;
            desc = "When set, timestamp is loaded from timestamp_sync on xtrigger posedge. Auto-clears after load.";
        } Resync[0:0] = 0x0;
        field {
            sw = rw;
            hw = r;
            desc = "Debug marker output value";
        } DebugMarker[8:1] = 0x0;
        field {
            sw = rw;
            hw = rw;
            desc = "When this bit is set, a cross trigger 0 event will cause the value from Timestamp register to be written into the TimestampCapture register";
        } TsCapture[9:9] = 0x0;
        field {
            sw = rw;
            hw = r;
            desc = "Reserved";
        } Rsvd1[63:10] = 0x0;
    } CDbgClaTimestampConfig @ 0x300;
    reg {
        desc = "Timestamp offset register. The Offset value is subtracted from the timestamp before comparing with incoming timestamp value.";
        regwidth = 64;

        field {
            sw = rw;
            hw = r;
            desc = "Timestamp offset value";
        } Offset[55:0] = 0x0;
        field {
            sw = rw;
            hw = r;
            desc = "Reserved";
        } Rsvd0[63:56] = 0x0;
    } CDbgClaTimestampOffset @ 0x308;
    reg {
        desc = "Used to define debug bus match event. Match event (0x2) is triggered when debug_bus & mask = match.";
        regwidth = 64;

        field {
            sw = rw;
            hw = r;
            desc = "Mask to be applied to debug bus before match";
        } Value[63:0] = 0x0;
    } CDbgSignalMask0Hi @ 0x400;
    reg {
        desc = "Used to define debug bus match event. Match event (0x2) is triggered when debug_bus & mask = match.";
        regwidth = 64;

        field {
            sw = rw;
            hw = r;
            desc = "Value used for debug bus match.";
        } Value[63:0] = 0x0;
    } CDbgSignalMatch0Hi @ 0x408;
    reg {
        desc = "Used to define debug bus match event. Match event (0x4) is triggered when debug_bus & mask = match.";
        regwidth = 64;

        field {
            sw = rw;
            hw = r;
            desc = "Mask to be applied to debug bus before match";
        } Value[63:0] = 0x0;
    } CDbgSignalMask1Hi @ 0x410;
    reg {
        desc = "Used to define debug bus match event. Match event (0x4) is triggered when debug_bus & mask = match.";
        regwidth = 64;

        field {
            sw = rw;
            hw = r;
            desc = "Value used for debug bus match.";
        } Value[63:0] = 0x0;
    } CDbgSignalMatch1Hi @ 0x418;
    reg {
        desc = "Used to define debug bus match event. Match event (0x1C) is triggered when debug_bus & mask = match.";
        regwidth = 64;

        field {
            sw = rw;
            hw = r;
            desc = "Mask to be applied to debug bus before match";
        } Value[63:0] = 0x0;
    } CDbgSignalMask2Hi @ 0x420;
    reg {
        desc = "Used to define debug bus match event. Match event (0x1C) is triggered when debug_bus & mask = match.";
        regwidth = 64;

        field {
            sw = rw;
            hw = r;
            desc = "Value used for debug bus match.";
        } Value[63:0] = 0x0;
    } CDbgSignalMatch2Hi @ 0x428;
    reg {
        desc = "Used to define debug bus match event. Match event (0x1D) is triggered when debug_bus & mask = match.";
        regwidth = 64;

        field {
            sw = rw;
            hw = r;
            desc = "Mask to be applied to debug bus before match";
        } Value[63:0] = 0x0;
    } CDbgSignalMask3Hi @ 0x430;
    reg {
        desc = "Used to define debug bus match event. Match event (0x1D) is triggered when debug_bus & mask = match.";
        regwidth = 64;

        field {
            sw = rw;
            hw = r;
            desc = "Value used for debug bus match.";
        } Value[63:0] = 0x0;
    } CDbgSignalMatch3Hi @ 0x438;
    reg {
        regwidth = 64;

        field {
            sw = rw;
            hw = r;
            desc = "Mode selection, 0: DBM off, 1: Normal debug mode, 2: DBM ID output mode, 3: Toggle Mode";
        } Dbmmode[1:0] = 0x0;
        field {
            sw = rw;
            hw = r;
            desc = "Unique DBM ID of the DBM instance";
        } Dbmid[7:2] = 0x0;
        field {
            sw = rw;
            hw = r;
        } Rsvd158[15:8] = 0x0;
        field {
            sw = rw;
            hw = r;
            desc = "Mux Select Bits for Lane 0. Split debug bus into 16 bit segments. Seg0 = debug bus [15:0], Seg1 = debug bus[31:16],.... If all bits are 0, Lane0 = Seg0, if bit[0] = 1, Lane0 = Seg4, if bit[1] =1, Lane0 = Seg5,...";
        } Muxselseg8[21:16] = 0x0;
        field {
            sw = rw;
            hw = r;
            desc = "Mux Select Bits for Lane 1. Split debug bus into 16 bit segments. Seg0 = debug bus [15:0], Seg1 = debug bus[31:16],.... If all bits are 0, Lane1= Seg1, if bit[0] = 1, Lane1 = Seg4, if bit[1] =1, Lane1 = Seg5,...";
        } Muxselseg9[27:22] = 0x0;
        field {
            sw = rw;
            hw = r;
            desc = "Mux Select Bits for Lane 2. Split debug bus into 16 bit segments. Seg0 = debug bus [15:0], Seg1 = debug bus[31:16],.... If all bits are 0, Lane2= Seg2, if bit[0] = 1, Lane2 = Seg4, if bit[1] =1, Lane2 = Seg5,...";
        } Muxselseg10[33:28] = 0x0;
        field {
            sw = rw;
            hw = r;
            desc = "Mux Select Bits for Lane 3. Split debug bus into 16 bit segments. Seg0 = debug bus [15:0], Seg1 = debug bus[31:16],.... If all bits are 0, Lane3= Seg3, if bit[0] = 1, Lane3 = Seg4, if bit[1] =1, Lane3 = Seg5,...";
        } Muxselseg11[39:34] = 0x0;
        field {
            sw = rw;
            hw = r;
        } Muxselseg12[45:40] = 0x0;
        field {
            sw = rw;
            hw = r;
        } Muxselseg13[51:46] = 0x0;
        field {
            sw = rw;
            hw = r;
        } Muxselseg14[57:52] = 0x0;
        field {
            sw = rw;
            hw = r;
        } Muxselseg15[63:58] = 0x0;
    } CDbgMuxSelHi @ 0x440;
    reg {
        desc = "3 registers to configure \"transition event\". This register is to select the signals of interest using a mask.";
        regwidth = 64;

        field {
            sw = rw;
            hw = r;
        } Value[63:0] = 0x0;
    } CDbgTransitionMaskHi @ 0x448;
    reg {
        desc = "3 registers to configure \"transition event\". The event is triggered on transition from Value A to Value B. This register specifies Value A.";
        regwidth = 64;

        field {
            sw = rw;
            hw = r;
        } Value[63:0] = 0x0;
    } CDbgTransitionFromValueHi @ 0x450;
    reg {
        desc = "3 registers to configure \"transition event\". The event is triggered on transition from Value A to Value B. This register specifies Value B.";
        regwidth = 64;

        field {
            sw = rw;
            hw = r;
        } Value[63:0] = 0x0;
    } CDbgTransitionToValueHi @ 0x458;
    reg {
        desc = "2 registers to configure \"ones count\" event. This register is to select the signals of interest using a mask.";
        regwidth = 64;

        field {
            sw = rw;
            hw = r;
        } Value[63:0] = 0x0;
    } CDbgOnesCountMaskHi @ 0x460;
    reg {
        desc = "Event triggered when a subset of debug signals change. The mask is used to select the subset of the debug signals.";
        regwidth = 64;

        field {
            sw = rw;
            hw = r;
        } Mask[63:0] = 0x0;
    } CDbgAnyChangeHi @ 0x468;
    reg {
        desc = "debug Bus Value when Node0 Eap0 Trigger is met.";
        regwidth = 64;

        field {
            sw = r;
            hw = w;
        } Value[63:0] = 0x0;
    } CDbgSignalSnapshotNode0Eap0Hi @ 0x470;
    reg {
        desc = "debug Bus Value when Node0 Eap1 Trigger is met.";
        regwidth = 64;

        field {
            sw = r;
            hw = w;
        } Value[63:0] = 0x0;
    } CDbgSignalSnapshotNode0Eap1Hi @ 0x478;
    reg {
        desc = "debug Bus Value when Node1 Eap0 Trigger is met.";
        regwidth = 64;

        field {
            sw = r;
            hw = w;
        } Value[63:0] = 0x0;
    } CDbgSignalSnapshotNode1Eap0Hi @ 0x480;
    reg {
        desc = "debug Bus Value when Node1 Eap0 Trigger is met.";
        regwidth = 64;

        field {
            sw = r;
            hw = w;
        } Value[63:0] = 0x0;
    } CDbgSignalSnapshotNode1Eap1Hi @ 0x488;
    reg {
        desc = "debug Bus Value when Node0 Eap0 Trigger is met.";
        regwidth = 64;

        field {
            sw = r;
            hw = w;
        } Value[63:0] = 0x0;
    } CDbgSignalSnapshotNode2Eap0Hi @ 0x490;
    reg {
        desc = "debug Bus Value when Node0 Eap1 Trigger is met.";
        regwidth = 64;

        field {
            sw = r;
            hw = w;
        } Value[63:0] = 0x0;
    } CDbgSignalSnapshotNode2Eap1Hi @ 0x498;
    reg {
        desc = "debug Bus Value when Node1 Eap0 Trigger is met.";
        regwidth = 64;

        field {
            sw = r;
            hw = w;
        } Value[63:0] = 0x0;
    } CDbgSignalSnapshotNode3Eap0Hi @ 0x4A0;
    reg {
        desc = "debug Bus Value when Node1 Eap0 Trigger is met.";
        regwidth = 64;

        field {
            sw = r;
            hw = w;
        } Value[63:0] = 0x0;
    } CDbgSignalSnapshotNode3Eap1Hi @ 0x4A8;
    reg {
        desc = "debug Bus Value when Node0 Eap2 Trigger is met.";
        regwidth = 64;

        field {
            sw = r;
            hw = w;
        } Value[63:0] = 0x0;
    } CDbgSignalSnapshotNode0Eap2Hi @ 0x4B0;
    reg {
        desc = "debug Bus Value when Node0 Eap3 Trigger is met.";
        regwidth = 64;

        field {
            sw = r;
            hw = w;
        } Value[63:0] = 0x0;
    } CDbgSignalSnapshotNode0Eap3Hi @ 0x4B8;
    reg {
        desc = "debug Bus Value when Node1 Eap2 Trigger is met.";
        regwidth = 64;

        field {
            sw = r;
            hw = w;
        } Value[63:0] = 0x0;
    } CDbgSignalSnapshotNode1Eap2Hi @ 0x4C0;
    reg {
        desc = "debug Bus Value when Node1 Eap3 Trigger is met.";
        regwidth = 64;

        field {
            sw = r;
            hw = w;
        } Value[63:0] = 0x0;
    } CDbgSignalSnapshotNode1Eap3Hi @ 0x4C8;
    reg {
        desc = "debug Bus Value when Node2 Eap2 Trigger is met.";
        regwidth = 64;

        field {
            sw = r;
            hw = w;
        } Value[63:0] = 0x0;
    } CDbgSignalSnapshotNode2Eap2Hi @ 0x4D0;
    reg {
        desc = "debug Bus Value when Node2 Eap3 Trigger is met.";
        regwidth = 64;

        field {
            sw = r;
            hw = w;
        } Value[63:0] = 0x0;
    } CDbgSignalSnapshotNode2Eap3Hi @ 0x4D8;
    reg {
        desc = "debug Bus Value when Node3 Eap2 Trigger is met.";
        regwidth = 64;

        field {
            sw = r;
            hw = w;
        } Value[63:0] = 0x0;
    } CDbgSignalSnapshotNode3Eap2Hi @ 0x4E0;
    reg {
        desc = "debug Bus Value when Node3 Eap3 Trigger is met.";
        regwidth = 64;

        field {
            sw = r;
            hw = w;
        } Value[63:0] = 0x0;
    } CDbgSignalSnapshotNode3Eap3Hi @ 0x4E8;
    reg {
        desc = "LFSR value.";
        regwidth = 64;

        field {
            sw = rw;
            hw = r;
            desc = "Enable the LFSR register.";
        } LfsrActive[0:0] = 0x0;
        field {
            sw = rw;
            hw = rw;
            desc = "Value of the LFSR register.";
        } Lfsr[63:1] = 0x0;
    } CDbgLfsr @ 0x4F0;
    reg {
        desc = "LFSR programming mask.";
        regwidth = 64;

        field {
            sw = rw;
            hw = r;
            desc = "Reserved.";
        } Rsvd0[0:0] = 0x0;
        field {
            sw = rw;
            hw = r;
            desc = "Value to mask the LFSR register.";
        } Mask[63:1] = 0x0;
    } CDbgLfsrMask @ 0x4F8;
    reg {
        desc = "Captured timestamp upper bits. When ts_capture is set in the timestamp config register, a cross trigger 0 event captures the timestamp upper bits into this register.";
        regwidth = 64;

        field {
            sw = r;
            hw = w;
            desc = "Timestamp capture value.";
        } Timestamp[63:0] = 0x0;
    } CDbgTimestampCapture @ 0x500;
    reg {
        desc = "Value for arithmetic comparison.";
        regwidth = 64;

        field {
            sw = rw;
            hw = r;
            desc = "Value for arithmetic comparison.";
        } Value[63:0] = 0x0;
    } CDbgCompare0Lo @ 0x508;
    reg {
        desc = "Value to mask the arithmetic comparison.";
        regwidth = 64;

        field {
            sw = rw;
            hw = r;
            desc = "Value to mask the arithmetic comparison.";
        } Value[63:0] = 0x0;
    } CDbgCompare0MaskLo @ 0x510;
    reg {
        desc = "Value for arithmetic comparison.";
        regwidth = 64;

        field {
            sw = rw;
            hw = r;
            desc = "Value for arithmetic comparison.";
        } Value[63:0] = 0x0;
    } CDbgCompare1Lo @ 0x518;
    reg {
        desc = "Value to mask the arithmetic comparison.";
        regwidth = 64;

        field {
            sw = rw;
            hw = r;
            desc = "Value to mask the arithmetic comparison.";
        } Value[63:0] = 0x0;
    } CDbgCompare1MaskLo @ 0x520;
    reg {
        desc = "Value for arithmetic comparison.";
        regwidth = 64;

        field {
            sw = rw;
            hw = r;
            desc = "Value for arithmetic comparison.";
        } Value[63:0] = 0x0;
    } CDbgCompare2Lo @ 0x528;
    reg {
        desc = "Value to mask the arithmetic comparison.";
        regwidth = 64;

        field {
            sw = rw;
            hw = r;
            desc = "Value to mask the arithmetic comparison.";
        } Value[63:0] = 0x0;
    } CDbgCompare2MaskLo @ 0x530;
    reg {
        desc = "Value for arithmetic comparison.";
        regwidth = 64;

        field {
            sw = rw;
            hw = r;
            desc = "Value for arithmetic comparison.";
        } Value[63:0] = 0x0;
    } CDbgCompare3Lo @ 0x538;
    reg {
        desc = "Value to mask the arithmetic comparison.";
        regwidth = 64;

        field {
            sw = rw;
            hw = r;
            desc = "Value to mask the arithmetic comparison.";
        } Value[63:0] = 0x0;
    } CDbgCompare3MaskLo @ 0x540;
    reg {
        desc = "Value for arithmetic comparison.";
        regwidth = 64;

        field {
            sw = rw;
            hw = r;
            desc = "Value for arithmetic comparison.";
        } Value[63:0] = 0x0;
    } CDbgCompare0Hi @ 0x548;
    reg {
        desc = "Value to mask the arithmetic comparison.";
        regwidth = 64;

        field {
            sw = rw;
            hw = r;
            desc = "Value to mask the arithmetic comparison.";
        } Value[63:0] = 0x0;
    } CDbgCompare0MaskHi @ 0x550;
    reg {
        desc = "Value for arithmetic comparison.";
        regwidth = 64;

        field {
            sw = rw;
            hw = r;
            desc = "Value for arithmetic comparison.";
        } Value[63:0] = 0x0;
    } CDbgCompare1Hi @ 0x558;
    reg {
        desc = "Value to mask the arithmetic comparison.";
        regwidth = 64;

        field {
            sw = rw;
            hw = r;
            desc = "Value to mask the arithmetic comparison.";
        } Value[63:0] = 0x0;
    } CDbgCompare1MaskHi @ 0x560;
    reg {
        desc = "Value for arithmetic comparison.";
        regwidth = 64;

        field {
            sw = rw;
            hw = r;
            desc = "Value for arithmetic comparison.";
        } Value[63:0] = 0x0;
    } CDbgCompare2Hi @ 0x568;
    reg {
        desc = "Value to mask the arithmetic comparison.";
        regwidth = 64;

        field {
            sw = rw;
            hw = r;
            desc = "Value to mask the arithmetic comparison.";
        } Value[63:0] = 0x0;
    } CDbgCompare2MaskHi @ 0x570;
    reg {
        desc = "Value for arithmetic comparison.";
        regwidth = 64;

        field {
            sw = rw;
            hw = r;
            desc = "Value for arithmetic comparison.";
        } Value[63:0] = 0x0;
    } CDbgCompare3Hi @ 0x578;
    reg {
        desc = "Value to mask the arithmetic comparison.";
        regwidth = 64;

        field {
            sw = rw;
            hw = r;
            desc = "Value to mask the arithmetic comparison.";
        } Value[63:0] = 0x0;
    } CDbgCompare3MaskHi @ 0x580;
    reg {
        desc = "Additional scratch register for DV and potential ECO usage";
        regwidth = 64;

        field {
            sw = rw;
            hw = r;
        } Data[63:0] = 0x0;
    } Scratch @ 0xFF8;
};

`endif
