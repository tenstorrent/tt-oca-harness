// SPDX-License-Identifier: Apache-2.0
// SPDX-FileCopyrightText: 2026 Tenstorrent USA, Inc.

// dst MMR block, generated by tools/regs/dfd_yaml_rdl.py from
// rtl/mmr/spec/dst_mmrs.yml. Do not edit; run `make ocah-regen-dfd-rdl`.
//
// Addresses are block-relative: the composite that instantiates this
// block places it at the offset mmrs.sv decodes.

`ifndef DFD_DST_RDL
`define DFD_DST_RDL

addrmap dfd_dst {
    reg {
        regwidth = 32;

        field {
            sw = rw;
            hw = r;
        } Trdstactive[0:0] = 0x0;
        field {
            sw = rw;
            hw = r;
        } Trdstenable[1:1] = 0x0;
        field {
            sw = rw;
            hw = rw;
        } Trdstinsttracing[2:2] = 0x0;
        field {
            sw = r;
            hw = w;
        } Trdstempty[3:3] = 0x1;
        field {
            sw = r;
            hw = r;
        } Trdstinstmode[6:4] = 0x6;
        field {
            sw = r;
            hw = r;
        } Trdstcontext[9:9] = 0x0;
        field {
            sw = rw;
            hw = r;
        } Trdstinsttriggerenable[11:11] = 0x0;
        field {
            sw = r;
            hw = r;
        } Trdstinststalloroverflow[12:12] = 0x0;
        field {
            sw = r;
            hw = r;
        } Trdstinststallena[13:13] = 0x0;
        field {
            sw = r;
            hw = r;
        } Trdstinhibitsrc[15:15] = 0x0;
        field {
            sw = rw;
            hw = r;
            desc = "When the field is set tp 2'b10, sent timestamp. All other vlaues not NA.";
        } Trdstsyncmode[17:16] = 0x0;
        field {
            sw = rw;
            hw = r;
            desc = "When trDstSyncMode is set to 2'b10, timestamp will be sent for every 2^(trDstSyncMax + 4) Cluster clocks.";
        } Trdstsyncmax[23:20] = 0x0;
        field {
            sw = rw;
            hw = r;
            desc = "bit[0]: XOR Enable, bit[1]: VLT Enable. Supported values : 2'b3 (XOR+VLT Compression), 2'b1 (XOR Compresion), 2'b0 (No Compression)";
        } Trdstformat[26:24] = 0x3;
    } Trdstcontrol @ 0x0;
    reg {
        regwidth = 32;

        field {
            sw = r;
            hw = r;
        } Trdstvermajor[3:0] = 0x1;
        field {
            sw = r;
            hw = r;
        } Trdstverminor[7:4] = 0x0;
        field {
            sw = r;
            hw = r;
        } Trdstcomptype[11:8] = 0x1;
        field {
            sw = r;
            hw = r;
        } Trdstprotocolmajor[19:16] = 0x1;
        field {
            sw = r;
            hw = r;
        } Trdstprotocolminor[23:20] = 0x0;
        field {
            sw = rw;
            hw = r;
            desc = "Specify frame length. Frame Length = trDstVendorFrameLength* 64 ; Frame Length should be a multiple of Bank Data Width.";
        } Trdstvendorframelength[27:24] = 0x1;
        field {
            sw = rw;
            hw = r;
            desc = "Specify Stream length. A stream starts with \"no compressed packet\". Stream length specifies number of frames before a non-compressed packet is sent.Stream Length = 32* 2^(trDstVendorStreamLength + 1)";
        } Trdstvendorstreamlength[30:28] = 0x4;
        field {
            sw = rw;
            hw = r;
            desc = "DST timestamp configuration. 0: timestamp input form external source (CoreTime). 1: timestamp from CLA timesync.";
        } Trdsttimestampconfig[31:31] = 0x0;
    } Trdstimpl @ 0x4;
    reg {
        regwidth = 32;

        field {
            sw = r;
            hw = r;
        } Trdstinstnoaddrdiff[0:0] = 0x0;
        field {
            sw = r;
            hw = r;
        } Trdstinstnotrapaddr[1:1] = 0x0;
        field {
            sw = r;
            hw = r;
        } Trdstinstenrepeatedhistory[8:8] = 0x0;
        field {
            sw = rw;
            hw = r;
        } Trdstsrcid[27:16] = 0x0;
        field {
            sw = rw;
            hw = r;
        } Trdstsrcbits[31:28] = 0x4;
    } Trdstinstfeatures @ 0x8;
    reg {
        regwidth = 32;

        field {
            sw = rw;
            hw = r;
            desc = "Trace Source ID";
        } TraceSourceId[3:0] = 0x0;
        field {
            sw = rw;
            hw = r;
            desc = "Use \"Filler Packet\" to align a stream of trace packets within a frame boundary.";
        } TraceFrameFillByte[11:4] = 0x81;
        field {
            sw = rw;
            hw = r;
            desc = "Use trDstImpl[trDstVendorFrameLength] for Frame Length programming. Register field ZBB-ed.";
        } FrameLenghtInBytes[15:12] = 0x2;
        field {
            sw = rw;
            hw = r;
            desc = "Enable Frame Mode (Frame Mode: Always pack \"frame length\" number of bytes for trace transmission). If flush to memory is stalled (due to silicon bug), we can have incomplete packets in memory. Frame Mode will help SW decoder to avoid reading incomplete trasnmitted packets. In Frame Mode, SW will get a memory pointer that is aligned to Frame Length. HW will ensure  there are no incomplete packets incluced in the region pointed by memory pointer.";
        } FrameModeEnable[20:20] = 0x1;
        field {
            sw = rw;
            hw = r;
            desc = "Closure Mode: 1: Close frame with a packet no larger than max packet size  before any overflow (due to packets crossing frame boundary). 0: Close frame when packets cross boundary. Push back packet crossing frame boundary to packet generator.";
        } FrameClosureMode[21:21] = 0x0;
    } CDbgDebugTraceCfg @ 0x1A0;
    reg {
        desc = "Scratch register (low) for DV and potential ECO usage";
        regwidth = 32;

        field {
            sw = rw;
            hw = r;
        } Data[31:0] = 0x0;
    } ScratchLo @ 0xFF8;
    reg {
        desc = "Scratch register (high) for DV and potential ECO usage";
        regwidth = 32;

        field {
            sw = rw;
            hw = r;
        } Data[31:0] = 0x0;
    } ScratchHi @ 0xFFC;
};

`endif
