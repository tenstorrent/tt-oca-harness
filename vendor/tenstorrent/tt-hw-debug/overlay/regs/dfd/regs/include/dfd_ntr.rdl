// SPDX-License-Identifier: Apache-2.0
// SPDX-FileCopyrightText: 2026 Tenstorrent USA, Inc.

// ntr MMR block, generated by tools/regs/dfd_yaml_rdl.py from
// rtl/mmr/spec/ntr_mmrs.yml. Do not edit; run `make ocah-regen-dfd-rdl`.
//
// Addresses are block-relative: the composite that instantiates this
// block places it at the offset mmrs.sv decodes.

`ifndef DFD_NTR_RDL
`define DFD_NTR_RDL

addrmap dfd_ntr {
    reg {
        regwidth = 32;

        field {
            sw = rw;
            hw = r;
        } Trteactive[0:0] = 0x0;
        field {
            sw = rw;
            hw = r;
        } Trteenable[1:1] = 0x0;
        field {
            sw = rw;
            hw = rw;
        } Trteinsttracing[2:2] = 0x0;
        field {
            sw = r;
            hw = w;
        } Trteempty[3:3] = 0x1;
        field {
            sw = rw;
            hw = r;
        } Trteinstmode[6:4] = 0x6;
        field {
            sw = rw;
            hw = r;
        } Trtecontext[9:9] = 0x0;
        field {
            sw = rw;
            hw = r;
        } Trteinsttriggerenable[11:11] = 0x0;
        field {
            sw = rw;
            hw = rw;
        } Trteinststalloroverflow[12:12] = 0x0;
        field {
            sw = rw;
            hw = r;
        } Trteinststallena[13:13] = 0x0;
        field {
            sw = rw;
            hw = r;
        } Trteinhibitsrc[15:15] = 0x0;
        field {
            sw = rw;
            hw = r;
        } Trtesyncmode[17:16] = 0x0;
        field {
            sw = rw;
            hw = r;
        } Trtesyncmax[23:20] = 0x0;
        field {
            sw = rw;
            hw = r;
        } Trteformat[26:24] = 0x1;
    } Trtecontrol @ 0x0;
    reg {
        regwidth = 32;

        field {
            sw = r;
            hw = r;
        } Trtevermajor[3:0] = 0x1;
        field {
            sw = r;
            hw = r;
        } Trteverminor[7:4] = 0x0;
        field {
            sw = r;
            hw = r;
        } Trtecomptype[11:8] = 0x1;
        field {
            sw = r;
            hw = r;
        } Trteprotocolmajor[19:16] = 0x1;
        field {
            sw = r;
            hw = r;
        } Trteprotocolminor[23:20] = 0x0;
        field {
            sw = rw;
            hw = r;
            desc = "Specify frame length. Frame Length = trTeVendorFrameLength* 64 ; Frame Length should be a multiple of Bank Data Width.";
        } Trtevendorframelength[27:24] = 0x1;
        field {
            sw = rw;
            hw = r;
            desc = "Enable bit for consuming CLA external trace action triggers for N-trace start/stop controls";
        } Trteclatriggerenable[28:28] = 0x0;
        field {
            sw = rw;
            hw = r;
            desc = "Enable bit for Tracing while in Patch mode";
        } Trtetracepatchenable[29:29] = 0x0;
    } Trteimpl @ 0x4;
    reg {
        regwidth = 32;

        field {
            sw = rw;
            hw = r;
        } Trteinstnoaddrdiff[0:0] = 0x0;
        field {
            sw = rw;
            hw = r;
        } Trteinstnotrapaddr[1:1] = 0x0;
        field {
            sw = r;
            hw = r;
        } Trteinstenrepeatedhistory[8:8] = 0x1;
        field {
            sw = rw;
            hw = r;
        } Trtesrcid[27:16] = 0x0;
        field {
            sw = rw;
            hw = r;
        } Trtesrcbits[31:28] = 0x4;
    } Trteinstfeatures @ 0x8;
    reg {
        regwidth = 32;

        field {
            sw = rw;
            hw = r;
        } Trteinstfilters[15:0] = 0x0;
    } Trteinstfilters @ 0xC;
    reg {
        regwidth = 32;

        field {
            sw = rw;
            hw = r;
        } Trtefilterenable[0:0] = 0x0;
        field {
            sw = rw;
            hw = r;
        } Trtefiltermatchprivilege[1:1] = 0x0;
    } Trtefilter0Control @ 0x10;
    reg {
        regwidth = 32;

        field {
            sw = rw;
            hw = r;
        } Trtefiltermatchchoiceprivilege[7:0] = 0x0;
    } Trtefilter0Matchinst @ 0x14;
    reg {
        regwidth = 32;

        field {
            sw = rw;
            hw = r;
        } Trtsactive[0:0] = 0x0;
        field {
            sw = r;
            hw = r;
        } Trtscount[1:1] = 0x0;
        field {
            sw = r;
            hw = r;
        } Trtsreset[2:2] = 0x0;
        field {
            sw = r;
            hw = r;
        } Trtsrunindebug[3:3] = 0x0;
        field {
            sw = r;
            hw = r;
        } Trtstype[6:4] = 0x1;
        field {
            sw = r;
            hw = r;
        } Trtsprescale[9:8] = 0x0;
        field {
            sw = rw;
            hw = r;
        } Trtsenable[15:15] = 0x0;
        field {
            sw = r;
            hw = r;
        } Trtswidth[29:24] = 0x37;
    } Trtscontrol @ 0x40;
    reg {
        regwidth = 32;

        field {
            sw = rw;
            hw = r;
            desc = "Trace Source ID";
        } TraceSourceId[3:0] = 0x0;
        field {
            sw = rw;
            hw = r;
            desc = "Use \"Filler Packet\" to align a stream of trace packets within a frame boundary.";
        } TraceFrameFillByte[11:4] = 0xFF;
        field {
            sw = rw;
            hw = r;
            desc = "Use trDstTe[trDstVendorFrameLength] for Frame Length programming. Register field ZBB-ed.";
        } FrameLenghtInBytes[15:12] = 0x2;
        field {
            sw = rw;
            hw = r;
            desc = "Enable Frame Mode (Frame Mode: Always pack \"frame length\" number of bytes for trace transmission). If flush to memory is stalled (due to silicon bug), we can have incomplete packets in memory. Frame Mode will help SW decoder to avoid reading incomplete trasnmitted packets. In Frame Mode, SW will get a memory pointer that is aligned to Frame Length. HW will ensure  there are no incomplete packets incluced in the region pointed by memory pointer.";
        } FrameModeEnable[20:20] = 0x1;
        field {
            sw = rw;
            hw = r;
            desc = "Closure Mode: 1: Close frame with a packet no larger than max packet size  before any overflow (due to packets crossing frame boundary). 0: Close frame when packets cross boundary. Push back packet crossing frame boundary to packet generator.";
        } FrameClosureMode[21:21] = 0x0;
    } CDbgNtraceFrameCfg @ 0x1A8;
    reg {
        desc = "Scratch register (low) for DV and potential ECO usage";
        regwidth = 32;

        field {
            sw = rw;
            hw = r;
        } Data[31:0] = 0x0;
    } ScratchLo @ 0xFF8;
    reg {
        desc = "Scratch register (high) for DV and potential ECO usage";
        regwidth = 32;

        field {
            sw = rw;
            hw = r;
        } Data[31:0] = 0x0;
    } ScratchHi @ 0xFFC;
};

`endif
