// SPDX-License-Identifier: Apache-2.0
// SPDX-FileCopyrightText: 2026 Tenstorrent USA, Inc.

`ifndef _PWM_RDL_DEFINED
`define _PWM_RDL_DEFINED

`include "opentitan_udps.rdl"

addrmap pwm #(longint unsigned N_OUTPUTS = 4) {
    name = "Pulse Width Modulator";
    desc = "Transmission of pulse-width modulated output signals with adjustable duty cycle";
    reg {
        field {
            sw = w;
            hw = r;
            swmod = true;
            desc = "Write 1 to trigger one alert event of this kind.";
        } fatal_fault[0:0] = 0x0;
    } external ALERT_TEST @ 0x0;
    reg {
        field {
            sw = rw;
            onwrite = wzc;
            hw = na;
            desc = "When true, all writable registers can be modified.
                When false, they become read-only. Defaults true, write
                zero to clear. This can be cleared after initial
                configuration at boot in order to lock in the supplied
                register settings.";
        } REGWEN[0:0] = 0x1;
    } REGWEN @ 0x4;
    reg {
        field {
            sw = rw;
            hw = r;
            swmod = true;
            desc = "Sets the period of each PWM beat to be (CLK_DIV+1)
               input clock periods.  Since PWM pulses are generated once
               every 2^(DC_RESN+1) beats, the period between output
               pulses is 2^(DC_RESN+1)*(CLK_DIV+1) times longer than the
               input clock period.";
        } CLK_DIV[26:0] = 0x8000;
        field {
            sw = rw;
            hw = r;
            swmod = true;
            desc = "Phase Resolution (logarithmic). All duty-cycle and phase
               shift registers represent fractional PWM cycles, expressed in
               units of 2^-16 PWM cycles. Each PWM cycle is divided
               into 2^(DC_RESN+1) time slices, and thus only the (DC_RESN+1)
               most significant bits of each phase or duty cycle register
               are relevant.";
        } DC_RESN[30:27] = 0x7;
        field {
            sw = rw;
            hw = r;
            swmod = true;
            desc = "Assert this bit to enable the PWM phase counter.
               Clearing this bit disables and resets the phase counter.";
        } CNTR_EN[31:31] = 0x0;
    } CFG @ 0x8;
    reg {
        field {
            sw = rw;
            hw = r;
            swmod = true;
            desc = "Write 1 to this bit to enable PWM pulses on the
               corresponding channel.";
        } EN[N_OUTPUTS-1:0] = 0x0;
    } PWM_EN @ 0xC;
    reg {
        field {
            sw = rw;
            hw = r;
            swmod = true;
            desc = "Write 1 to this bit to invert the output for each channel,
               so that the corresponding output is active-low.";
        } INVERT[N_OUTPUTS-1:0] = 0x0;
    } INVERT @ 0x10;
    reg {
        field {
            sw = rw;
            hw = r;
            swmod = true;
            desc = "Phase delay of the PWM leading edge, in units of 2^(-16) PWM
               cycles. The leading edge will be the rising edge of the output
               signal unless the corresponding INVERT bit is set.";
        } PHASE_DELAY[15:0] = 0x0;
        field {
            sw = rw;
            hw = r;
            swmod = true;
            desc = "Modulates blink behavior to create a heartbeat effect. When
               HTBT_EN is set, the duty cycle increases (or decreases)
               linearly from DUTY_CYCLE.A to DUTY_CYCLE.B and back, in
               steps of (BLINK_PARAM.Y+1), with an increment (decrement)
               once every (BLINK_PARAM.X+1) PWM cycles.

               When HTBT_EN is cleared, the standard blink behavior applies,
               meaning that the output duty cycle alternates between DUTY_CYCLE.A for
               (BLINK_PARAM.X+1) pulses and DUTY_CYCLE.B for
               (BLINK_PARAM.Y+1) pulses.";
        } HTBT_EN[30:30] = 0x0;
        field {
            sw = rw;
            hw = r;
            swmod = true;
            desc = "Enables blink (or heartbeat).  If cleared, the output duty
               cycle will remain constant at DUTY_CYCLE.A. Enabling this
               bit  causes the PWM duty cycle to alternate between
               DUTY_CYCLE.A and DUTY_CYCLE.B";
        } BLINK_EN[31:31] = 0x0;
    } PWM_PARAM[N_OUTPUTS] @ 0x14 += 0x4;
    reg {
        field {
            sw = rw;
            hw = r;
            swmod = true;
            desc = "The initial duty cycle for PWM output, in units
               of 2^(-16)ths of a pulse cycle. The actual precision is
               however limited to the (DC_RESN+1) most significant bits.
               This setting applies continuously when not blinking
               and determines the initial duty cycle when blinking.";
        } A[15:0] = 0x7FFF;
        field {
            sw = rw;
            hw = r;
            swmod = true;
            desc = "The target duty cycle for PWM output, in units
               of 2^(-16)ths of a pulse cycle. The actual precision is
               however limited to the (DC_RESN+1) most significant bits.
               This setting only applies when blinking, and determines
               the target duty cycle.";
        } B[31:16] = 0x7FFF;
    } DUTY_CYCLE[N_OUTPUTS] @ 0x14 + 4 * N_OUTPUTS += 0x4;
    reg {
        field {
            sw = rw;
            hw = r;
            swmod = true;
            desc = "This blink-rate timing parameter has two different
               interpretations depending on whether or not the heartbeat
               feature is enabled. If heartbeat is disabled, a blinking
               PWM will pulse at duty cycle A for (X+1) pulse cycles before
               switching to duty cycle B. If heartbeat is enabled
               the duty cycle will start at duty cycle A, but
               will be incremented (or decremented) every (X+1) cycles.
               In heartbeat mode is enabled, the size of each step is
               controlled by BLINK_PARAM.Y.";
        } X[15:0] = 0x0;
        field {
            sw = rw;
            hw = r;
            swmod = true;
            desc = "This blink-rate timing parameter has two different
               interpretations depending on whether or not the heartbeat
               feature is enabled. If heartbeat is disabled, a blinking
               PWM will pulse at duty cycle B for (Y+1) pulse cycles
               before returning to duty cycle A. If heartbeat is enabled
               the duty cycle will increase (or decrease) by (Y+1) units
               every time it is incremented (or decremented).";
        } Y[31:16] = 0x0;
    } BLINK_PARAM[N_OUTPUTS] @ 0x14 + 8 * N_OUTPUTS += 0x4;
};

`endif // _PWM_RDL_DEFINED
