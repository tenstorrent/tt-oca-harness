// SPDX-License-Identifier: Apache-2.0
// SPDX-FileCopyrightText: 2026 Tenstorrent USA, Inc.

`ifndef _HMAC_RDL_DEFINED
`define _HMAC_RDL_DEFINED

`include "opentitan_udps.rdl"

addrmap hmac {
    name = "HMAC Accelerator";
    desc = "Accelerator for SHA-2 256/384/512-based keyed HMAC and the hash function";
    reg {
        field {
            sw = rw;
            onwrite = woclr;
            hw = rw;
            desc = "HMAC/SHA-2 has completed.";
        } hmac_done[0:0] = 0x0;
        field {
            sw = r;
            hw = rw;
            desc = "The message FIFO is empty.
            This interrupt is raised only if the message FIFO is actually writable by software, i.e., if all of the following conditions are met:
            i) The HMAC block is not running in HMAC mode and performing the second round of computing the final hash of the outer key as well as the result of the first round using the inner key.
            ii) Software has not yet written the Process or Stop command to finish the hashing operation.
            For the interrupt to be raised, the message FIFO must also have been full previously.
            Otherwise, the hardware empties the FIFO faster than software can fill it and there is no point in interrupting the software to inform it about the message FIFO being empty.";
        } fifo_empty[1:1] = 0x0;
        field {
            sw = rw;
            onwrite = woclr;
            hw = rw;
            desc = "HMAC error has occurred. ERR_CODE register shows which error occurred.";
        } hmac_err[2:2] = 0x0;
    } INTR_STATE @ 0x0;
    reg {
        field {
            sw = rw;
            hw = r;
            desc = "Enable interrupt when !!INTR_STATE.hmac_done is set.";
        } hmac_done[0:0] = 0x0;
        field {
            sw = rw;
            hw = r;
            desc = "Enable interrupt when !!INTR_STATE.fifo_empty is set.";
        } fifo_empty[1:1] = 0x0;
        field {
            sw = rw;
            hw = r;
            desc = "Enable interrupt when !!INTR_STATE.hmac_err is set.";
        } hmac_err[2:2] = 0x0;
    } INTR_ENABLE @ 0x4;
    reg {
        field {
            sw = w;
            hw = r;
            swmod = true;
            desc = "Write 1 to force !!INTR_STATE.hmac_done to 1.";
        } hmac_done[0:0] = 0x0;
        field {
            sw = w;
            hw = r;
            swmod = true;
            desc = "Write 1 to force !!INTR_STATE.fifo_empty to 1.";
        } fifo_empty[1:1] = 0x0;
        field {
            sw = w;
            hw = r;
            swmod = true;
            desc = "Write 1 to force !!INTR_STATE.hmac_err to 1.";
        } hmac_err[2:2] = 0x0;
    } external INTR_TEST @ 0x8;
    reg {
        field {
            sw = w;
            hw = r;
            swmod = true;
            desc = "Write 1 to trigger one alert event of this kind.";
        } fatal_fault[0:0] = 0x0;
    } external ALERT_TEST @ 0xC;
    reg {
        field {
            sw = rw;
            hw = rw;
            swmod = true;
            desc = "HMAC datapath enable.

            If this bit is 1, HMAC operates when `hash_start` toggles.";
        } hmac_en[0:0];
        field {
            sw = rw;
            hw = rw;
            swmod = true;
            desc = "SHA-2 enable.

             If 0, the SHA engine will not initiate compression, this is used to stop operation of the SHA-2 engine until configuration has been done.
             When the SHA-2 engine is disabled the digest is cleared.";
        } sha_en[1:1];
        field {
            sw = rw;
            hw = rw;
            swmod = true;
            desc = "Endian swap.

            If 0, each value will be added to the message in little-endian byte order.
            The value is written to MSG_FIFO same to the SW writes.
            If 1, then each individual multi-byte value, regardless of its alignment, written to !!MSG_FIFO will be added to the message in big-endian byte order.
            A message written to !!MSG_FIFO one byte at a time will not be affected by this setting.
            From a hardware perspective byte swaps are performed on a TL-UL word granularity.";
        } endian_swap[2:2] = 0x0;
        field {
            sw = rw;
            hw = rw;
            swmod = true;
            desc = "Digest register byte swap.

            If 1 the value in each digest output register is converted to big-endian byte order.
            This setting does not affect the order of the digest output registers, !!DIGEST_0 still contains the first 4 bytes of the digest.";
        } digest_swap[3:3] = 0x0;
        field {
            sw = rw;
            hw = rw;
            swmod = true;
            desc = "Key register byte swap (deprecated: KEY path is for DV only; production uses key manager sideload).

            If 1 the endianness of each KEY_* register is swapped. Default value (value 0) is big endian representation of the KEY_* CSRs.";
        } key_swap[4:4] = 0x0;
        field {
            sw = rw;
            hw = rw;
            swmod = true;
            desc = "Digest size configuration.

            This is a 4-bit one-hot encoded field to select digest size for either HMAC or SHA-2.
            Invalid/unsupported values, i.e., values that don't correspond to SHA2_256, SHA2_384, or SHA2_512, are mapped to SHA2_None.";
        } digest_size[8:5] = 0x8;
        field {
            sw = rw;
            hw = rw;
            swmod = true;
            desc = "Key length configuration.

            This is a 6-bit one-hot encoded field to configure the key length for HMAC.

            The HMAC can be programmed with the following key lengths: 128-bit, 256-bit, 384-bit, 512-bit and 1024-bit.
            But the HMAC supports any arbitrary key length: the software should configure the HMAC with the next largest supported key length and concatenate zeros to reach the programmed key length.
            The position of these zeros depends on the endianness, thus on the programmed [`CFG.key_swap`](registers.md#cfg--key_swap).
            For example, for an 80-bit key, HMAC should be configured with an 128-bit key length, fed with the 80-bit key and with 48 zero-bits.

            Note that the key length cannot be greater than the block size: up to 1024-bit for SHA-2 384/512 and up to 512-bit for SHA-2 256.
            The value of this register is irrelevant when only SHA-2 (not keyed HMAC) is configured.
            However, for HMAC mode (`hmac_en == 1`), when HMAC is triggered to start while !!KEY_LENGTH holds `Key_None` or !!KEY_LENGTH holds `Key_1024` for !!DIGEST_SIZE = `SHA2_256`, starting is blocked and an error is signalled to SW.";
        } key_length[14:9] = 0x20;
    } external CFG @ 0x10;
    reg {
        field {
            sw = w;
            onwrite = woclr;
            hw = r;
            swmod = true;
            desc = "If 1 is written into this field, SHA-2 or HMAC begins its operation.
            CPU must configure relative information first, such as the digest size, secret key and the key length.";
        } hash_start[0:0];
        field {
            sw = w;
            onwrite = woclr;
            hw = r;
            swmod = true;
            desc = "If 1 is written to this field, SHA-2 or HMAC calculates the digest or signing based on currently received message.";
        } hash_process[1:1];
        field {
            sw = w;
            onwrite = woclr;
            hw = r;
            swmod = true;
            desc = "When 1 is written to this field, SHA-2 or HMAC will afterwards set the `hmac_done` interrupt as soon as the current block has been hashed.
            The hash can then be read from the registers !!DIGEST_0 to !!DIGEST_15.
            Together with the message length in !!MSG_LENGTH_LOWER and !!MSG_LENGTH_UPPER, this forms the information that has to be saved before switching context.";
        } hash_stop[2:2];
        field {
            sw = w;
            onwrite = woclr;
            hw = r;
            swmod = true;
            desc = "When 1 is written to this field, SHA-2 or HMAC will continue hashing based on the current hash in the digest registers and the message length, which both have to be restored to switch context.";
        } hash_continue[3:3];
    } external CMD @ 0x14;
    reg {
        field {
            sw = r;
            hw = w;
            desc = "HMAC idle status.
            When IDLE, the `DIGEST` and the `MSG_LENGTH_LOWER`/`MSG_LENGTH_UPPER` can be written to from SW which enables restoring context (to support context switching).";
        } hmac_idle[0:0] = 0x1;
        field {
            sw = r;
            hw = w;
            desc = "FIFO empty";
        } fifo_empty[1:1] = 0x1;
        field {
            sw = r;
            hw = w;
            desc = "FIFO full. Data written to the FIFO whilst it is full will cause back-pressure on the interconnect";
        } fifo_full[2:2];
        field {
            sw = r;
            hw = w;
            desc = "FIFO entry count.";
        } fifo_depth[9:4];
    } external STATUS @ 0x18;
    reg {
        field {
            sw = r;
            hw = w;
            desc = "If an error interrupt occurs, this register has information of error cause.
            Please take a look at `hw/ip/prim/rtl/prim_sha2_pkg.sv:err_code_e enum type.";
        } err_code[31:0] = 0x0;
    } ERR_CODE @ 0x1C;
    reg {
        field {
            sw = w;
            hw = r;
            swmod = true;
            desc = "Secret value";
        } secret[31:0];
    } external WIPE_SECRET @ 0x20;
    reg {
        field {
            sw = w;
            hw = rw;
            swmod = true;
            desc = "32-bit chunk of 1024-bit secret key";
        } key_0[31:0];
    } external KEY[32] @ 0x24 += 0x4;
    reg {
        field {
            sw = rw;
            hw = rw;
            swmod = true;
            desc = "32-bit chunk of 512-bit digest";
        } digest_0[31:0];
    } external DIGEST[16] @ 0xA4 += 0x4;
    reg {
        field {
            sw = rw;
            hw = rw;
            swmod = true;
            desc = "Message Length [31:0]";
        } v[31:0];
    } external MSG_LENGTH_LOWER @ 0xE4;
    reg {
        field {
            sw = rw;
            hw = rw;
            swmod = true;
            desc = "Message Length [63:32]";
        } v[31:0];
    } external MSG_LENGTH_UPPER @ 0xE8;
    mem {
        memwidth = 0x20;
        mementries = 0x400;
    } external MSG_FIFO @ 0x1000;
};

`endif // _HMAC_RDL_DEFINED
