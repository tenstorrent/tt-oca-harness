// SPDX-License-Identifier: Apache-2.0
// SPDX-FileCopyrightText: 2026 Tenstorrent USA, Inc.

`ifndef _EDN_RDL_DEFINED
`define _EDN_RDL_DEFINED

`include "opentitan_udps.rdl"

addrmap edn {
    name = "Entropy Distribution Network";
    desc = "Distributes random numbers produced by CSRNG to hardware blocks";
    reg {
        field {
            sw = rw;
            onwrite = woclr;
            hw = rw;
            desc = "Asserted when a software CSRNG request has completed.";
        } edn_cmd_req_done[0:0] = 0x0;
        field {
            sw = rw;
            onwrite = woclr;
            hw = rw;
            desc = "Asserted when a FIFO error occurs.";
        } edn_fatal_err[1:1] = 0x0;
    } INTR_STATE @ 0x0;
    reg {
        field {
            sw = rw;
            hw = r;
            desc = "Enable interrupt when !!INTR_STATE.edn_cmd_req_done is set.";
        } edn_cmd_req_done[0:0] = 0x0;
        field {
            sw = rw;
            hw = r;
            desc = "Enable interrupt when !!INTR_STATE.edn_fatal_err is set.";
        } edn_fatal_err[1:1] = 0x0;
    } INTR_ENABLE @ 0x4;
    reg {
        field {
            sw = w;
            hw = r;
            swmod = true;
            desc = "Write 1 to force !!INTR_STATE.edn_cmd_req_done to 1.";
        } edn_cmd_req_done[0:0] = 0x0;
        field {
            sw = w;
            hw = r;
            swmod = true;
            desc = "Write 1 to force !!INTR_STATE.edn_fatal_err to 1.";
        } edn_fatal_err[1:1] = 0x0;
    } external INTR_TEST @ 0x8;
    reg {
        field {
            sw = w;
            hw = r;
            swmod = true;
            desc = "Write 1 to trigger one alert event of this kind.";
        } recov_alert[0:0] = 0x0;
        field {
            sw = w;
            hw = r;
            swmod = true;
            desc = "Write 1 to trigger one alert event of this kind.";
        } fatal_alert[1:1] = 0x0;
    } external ALERT_TEST @ 0xC;
    reg {
        field {
            sw = rw;
            onwrite = wzc;
            hw = na;
            desc = "When true, the CTRL can be written by software.
            When false, this field read-only. Defaults true, write zero to clear.
            Note that this needs to be cleared after initial configuration at boot in order to
            lock in the listed register settings.";
        } REGWEN[0:0] = 0x1;
    } REGWEN @ 0x10;
    reg {
        field {
            enum MultiBitBool4 {
                True = 6;
                False = 9;
            } ;
            sw = rw;
            hw = r;
            desc = "Setting this field to kMultiBitBool4True enables the EDN module. The modules of the
            entropy complex may only be enabled and disabled in a specific order, see
            Programmers Guide for details.";
            encode = MultiBitBool4;
        } EDN_ENABLE[3:0] = 0x9;
        field {
            enum MultiBitBool4 {
                True = 6;
                False = 9;
            } ;
            sw = rw;
            hw = r;
            desc = "Setting this field to kMultiBitBool4True enables the boot-time request mode.
            In this mode, EDN automatically sends a boot-time request to the CSRNG application interface.
            The purpose of this mode is to request entropy as fast as possible after reset, and during chip boot time.

            Note that this takes precedence over the AUTO_REQ_MODE field: If both fields are set, EDN enters boot-time request mode.
            If none of the fields are set, EDN enters Software Port Mode upon enabling.";
            encode = MultiBitBool4;
        } BOOT_REQ_MODE[7:4] = 0x9;
        field {
            enum MultiBitBool4 {
                True = 6;
                False = 9;
            } ;
            sw = rw;
            hw = r;
            desc = "Setting this field to kMultiBitBool4True enables auto request mode.
            In this mode, EDN automatically sends `generate` and `reseed` command requests to the CSRNG application interface.
            The purpose of this mode is to continuously deliver entropy to endpoints without firmware intervention.

            For this to work, firmware has to 1) configure the !!GENERATE_CMD, !!RESEED_CMD, and !!MAX_NUM_REQS_BETWEEN_RESEEDS registers, and 2) to issue the first `instantiate` command via the !!SW_CMD_REQ register.
            Once this command has been acknowledged by CSRNG, the first `generate` command is sent out automatically, and a `reseed` command is sent after every MAX_NUM_REQS_BETWEEN_RESEEDS number of `generate` commands.

            Note that the BOOT_REQ_MODE field takes precedence over this field: If both fields are set, EDN enters boot-time request mode.
            If none of the fields are set, EDN enters Software Port Mode upon enabling.";
            encode = MultiBitBool4;
        } AUTO_REQ_MODE[11:8] = 0x9;
        field {
            enum MultiBitBool4 {
                True = 6;
                False = 9;
            } ;
            sw = rw;
            hw = r;
            desc = "Setting this field to kMultiBitBool4True clears the two command FIFOs: the
            RESEED_CMD FIFO and the GENERATE_CMD FIFO. This field must be
            set to the reset state by software before any further commands can be issued to
            these FIFOs.";
            encode = MultiBitBool4;
        } CMD_FIFO_RST[15:12] = 0x9;
    } CTRL @ 0x14;
    reg {
        field {
            sw = rw;
            hw = r;
            desc = "This field is used as the value for the `instantiate` command at boot time.

            See [Command Header](../../csrng/doc/theory_of_operation.md#command-header) for the meaning of the individual bits.
            Note that the hardware only supports a value of 0 for the `clen` field.
            If `clen` has a different value, EDN will hang.
            Fixing this requires disabling and restarting both EDN and CSRNG.";
        } BOOT_INS_CMD[31:0] = 0x901;
    } BOOT_INS_CMD @ 0x18;
    reg {
        field {
            sw = rw;
            hw = r;
            desc = "This field is used as the value for the `generate` command at boot time.

            See [Command Header](../../csrng/doc/theory_of_operation.md#command-header) for the meaning of the individual bits.
            Note that the hardware only supports a value of 0 for the `clen` field.
            If `clen` has a different value, EDN will hang.
            Fixing this requires disabling and restarting both EDN and CSRNG.";
        } BOOT_GEN_CMD[31:0] = 0xFFF003;
    } BOOT_GEN_CMD @ 0x1C;
    reg {
        field {
            sw = w;
            hw = r;
            swmod = true;
            desc = "Any CSRNG action can be initiated by writing a CSRNG command to this register.
            Before any write operation to this register, firmware must read !!SW_CMD_STS to check whether EDN is ready to receive a new command or the next word of a previously started command.

            While !!CTRL.AUTO_REQ_MODE is set, only the first instantiate command has any effect.
            After that command has been processed, writes to this register will have no effect on operation, until !!CTRL.AUTO_REQ_MODE is de-asserted and the state machine of EDN enters the `SwPortMode` state.

            Refer to the [CSRNG documentation](../../csrng/doc/theory_of_operation.md#general-command-format) for details on the command format.";
        } SW_CMD_REQ[31:0];
    } external SW_CMD_REQ @ 0x20;
    reg {
        field {
            sw = r;
            hw = w;
            desc = "This bit indicates when !!SW_CMD_REQ is ready to accept the next word.
            This bit has to be polled before each word of a command is written to !!SW_CMD_REQ.
            0b0: The EDN is not ready to accept the next word yet.
            0b1: The EDN is ready to accept the next word.";
        } CMD_REG_RDY[0:0] = 0x0;
        field {
            sw = r;
            hw = w;
            desc = "This bit indicates when the EDN is ready to accept the next command.
            Before starting to write a new command to !!SW_CMD_REQ, this field needs to be polled.
            0b0: The EDN is not ready to accept commands or the last command hasn't been acked yet.
            0b1: The EDN is ready to accept the next command.";
        } CMD_RDY[1:1] = 0x0;
        field {
            sw = r;
            hw = w;
            desc = "This one bit field indicates when a SW command has been acknowledged by the CSRNG.
            It is set to low each time a new command is written to !!SW_CMD_REQ.
            The field is set to high once a SW command request has been acknowledged by the CSRNG.
            0b0: The last SW command has not been acknowledged yet.
            0b1: The last SW command has been acknowledged.";
        } CMD_ACK[2:2] = 0x0;
        field {
            sw = r;
            hw = w;
            desc = "This field represents the status code returned with the CSRNG application command ack.
            It is updated each time a SW command is acknowledged by CSRNG.
            To check whether a command was successful, wait for !!INTR_STATE.EDN_CMD_REQ_DONE or
            !!SW_CMD_STS.CMD_ACK to be high and then check the value of this field.
            A description of the command status types can be found [here](../../csrng/doc/registers.md#sw_cmd_sts--cmd_sts).";
        } CMD_STS[5:3] = 0x0;
    } SW_CMD_STS @ 0x24;
    reg {
        field {
            sw = r;
            hw = w;
            desc = "This one bit field indicates whether the EDN is in the hardware controlled boot mode.
            0b0: The EDN is not in boot mode.
            0b1: The EDN is in boot mode.";
        } BOOT_MODE[0:0] = 0x0;
        field {
            sw = r;
            hw = w;
            desc = "This one bit field indicates whether the EDN is in the hardware controlled part of auto mode.
            The instantiate command is issued via SW interface and is thus not part of the hardware controlled part of auto mode.
            0b0: The EDN is not in the hardware controlled part of auto mode.
            0b1: The EDN is in the hardware controlled part of auto mode.";
        } AUTO_MODE[1:1] = 0x0;
        field {
            sw = r;
            hw = w;
            desc = "This field contains the application command type of the hardware controlled command issued last.
            The application command selects one of five operations to perform.
            A description of the application command types can be found [here](../../csrng/doc/theory_of_operation.md#command-description).";
        } CMD_TYPE[5:2] = 0x0;
        field {
            sw = r;
            hw = w;
            desc = "This one bit field indicates when a HW command has been acknowledged by the CSRNG.
            It is set to low each time a new command is sent to the CSRNG.
            The field is set to high once a HW command request has been acknowledged by the CSRNG.
            0b0: The last HW command has not been acknowledged yet.
            0b1: The last HW command has been acknowledged.";
        } CMD_ACK[6:6] = 0x0;
        field {
            sw = r;
            hw = w;
            desc = "This field represents the status code returned with the CSRNG application command ack.
            It is updated each time a HW command is acknowledged by CSRNG.
            A description of the command status types can be found [here](../../csrng/doc/registers.md#sw_cmd_sts--cmd_sts).";
        } CMD_STS[9:7] = 0x0;
    } HW_CMD_STS @ 0x28;
    reg {
        field {
            sw = w;
            hw = r;
            swmod = true;
            desc = "Writing this register will fill a FIFO with up to 13 command words (32b words).
            When running in auto request mode, this FIFO is used to automatically send out a `reseed` command to the CSRNG application interface after every MAX_NUM_REQS_BETWEEN_RESEEDS number of `generate` commands.

            See [General Command Format](../../csrng/doc/theory_of_operation.md#general-command-format) for details about the command format.

            Note that the number of additional data words provided must match the value of the `clen` field of the first word.
            Otherwise, undefined behavior may result.
            If more than 13 entries are written to the FIFO, they are ignored and EDN signals an `edn_fatal_err` interrupt as well as a fatal alert.";
        } RESEED_CMD[31:0];
    } external RESEED_CMD @ 0x2C;
    reg {
        field {
            sw = w;
            hw = r;
            swmod = true;
            desc = "Writing this register will fill a FIFO with up to 13 command words (32b words).
            When running auto request mode, this FIFO is used to automatically send out `generate` commands to the CSRNG
            application interface.

            See [General Command Format](../../csrng/doc/theory_of_operation.md#general-command-format) for details about the command format.

            Note that the number of additional data words provided must match the value of the `clen` field of the first word.
            Otherwise, undefined behavior may result.
            If more than 13 entries are written to the FIFO, they are ignored and EDN signals an `edn_fatal_err` interrupt as well as a fatal alert.";
        } GENERATE_CMD[31:0];
    } external GENERATE_CMD @ 0x30;
    reg {
        field {
            sw = rw;
            hw = r;
            swmod = true;
            desc = "Setting this field will set the number of `generate` command requests that are made
            to CSRNG before a reseed request is made.
            This value only has meaning when running in auto request mode.
            This register supports a maximum of 2^32 `generate` requests between reseeds.
            This register will be used by a counter that counts down, triggering an automatic `reseed` request when it reaches zero.

            Note that this value must be chosen smaller than or equal to the value configured in the [`RESEED_INTERVAL` register of CSRNG](../../csrng/doc/registers.md#reseed-interval).";
        } MAX_NUM_REQS_BETWEEN_RESEEDS[31:0] = 0x0;
    } MAX_NUM_REQS_BETWEEN_RESEEDS @ 0x34;
    reg {
        field {
            sw = rw;
            onwrite = wzc;
            hw = w;
            desc = "This bit is set when the EDN_ENABLE field is set to an illegal value,
            something other than kMultiBitBool4True or kMultiBitBool4False.
            Writing a zero resets this status bit.";
        } EDN_ENABLE_FIELD_ALERT[0:0] = 0x0;
        field {
            sw = rw;
            onwrite = wzc;
            hw = w;
            desc = "This bit is set when the BOOT_REQ_MODE field is set to an illegal value,
            something other than kMultiBitBool4True or kMultiBitBool4False.
            Writing a zero resets this status bit.";
        } BOOT_REQ_MODE_FIELD_ALERT[1:1] = 0x0;
        field {
            sw = rw;
            onwrite = wzc;
            hw = w;
            desc = "This bit is set when the !!CTRL.AUTO_REQ_MODE field is set to an illegal value,
            something other than kMultiBitBool4True or kMultiBitBool4False.
            Writing a zero resets this status bit.";
        } AUTO_REQ_MODE_FIELD_ALERT[2:2] = 0x0;
        field {
            sw = rw;
            onwrite = wzc;
            hw = w;
            desc = "This bit is set when the CMD_FIFO_RST field is set to an illegal value,
            something other than kMultiBitBool4True or kMultiBitBool4False.
            Writing a zero resets this status bit.";
        } CMD_FIFO_RST_FIELD_ALERT[3:3] = 0x0;
        field {
            sw = rw;
            onwrite = wzc;
            hw = w;
            desc = "This bit is set when the interal entropy bus value is equal to the prior
            valid value on the bus, indicating a possible attack.
            Writing a zero resets this status bit.";
        } EDN_BUS_CMP_ALERT[12:12] = 0x0;
        field {
            sw = rw;
            onwrite = wzc;
            hw = w;
            desc = "This bit is set when the CSRNG returns an acknowledgement where the status signal is non-zero.
            Writing a zero resets this status bit.";
        } CSRNG_ACK_ERR[13:13] = 0x0;
    } RECOV_ALERT_STS @ 0x38;
    reg {
        field {
            sw = r;
            hw = w;
            desc = "This bit will be set to one when an error has been detected for the
            reseed command FIFO. The type of error is reflected in the type status
            bits (bits 28 through 30 of this register).
            When this bit is set, a fatal error condition will result.";
        } SFIFO_RESCMD_ERR[0:0] = 0x0;
        field {
            sw = r;
            hw = w;
            desc = "This bit will be set to one when an error has been detected for the
            generate command FIFO. The type of error is reflected in the type status
            bits (bits 28 through 30 of this register).
            When this bit is set, a fatal error condition will result.
            This bit will stay set until the next reset.";
        } SFIFO_GENCMD_ERR[1:1] = 0x0;
        field {
            sw = r;
            hw = w;
            desc = "This bit will be set to one when an illegal state has been detected for the
            EDN ack stage state machine. This error will signal a fatal alert.
            This bit will stay set until the next reset.";
        } EDN_ACK_SM_ERR[20:20] = 0x0;
        field {
            sw = r;
            hw = w;
            desc = "This bit will be set to one when an illegal state has been detected for the
            EDN main stage state machine. This error will signal a fatal alert.
            This bit will stay set until the next reset.";
        } EDN_MAIN_SM_ERR[21:21] = 0x0;
        field {
            sw = r;
            hw = w;
            desc = "This bit will be set to one when a hardened counter has detected an error
            condition. This error will signal a fatal alert.
            This bit will stay set until the next reset.";
        } EDN_CNTR_ERR[22:22] = 0x0;
        field {
            sw = r;
            hw = w;
            desc = "This bit will be set to one when any of the source bits (bits 0 through 1 of this register) are asserted as a result of an error pulse generated from any full FIFO that has received a write pulse.
            This bit will stay set until the next reset.";
        } FIFO_WRITE_ERR[28:28] = 0x0;
        field {
            sw = r;
            hw = w;
            desc = "This bit will be set to one when any of the source bits (bits 0 through 1 of this register) are asserted as a result of an error pulse generated from any empty FIFO that has received a read pulse.
            This bit will stay set until the next reset.";
        } FIFO_READ_ERR[29:29] = 0x0;
        field {
            sw = r;
            hw = w;
            desc = "This bit will be set to one when any of the source bits (bits 0 through 1 of this register) are asserted as a result of an error pulse generated from any FIFO where both the empty and full status bits are set or in case of error conditions inside the hardened counters.
            This bit will stay set until the next reset.";
        } FIFO_STATE_ERR[30:30] = 0x0;
    } ERR_CODE @ 0x3C;
    reg {
        field {
            sw = rw;
            hw = r;
            swmod = true;
            desc = "Setting this field will set the bit number for which an error
            will be forced in the hardware. This bit number is that same one
            found in the !!ERR_CODE register. The action of writing this
            register will force an error pulse. The sole purpose of this
            register is to test that any error properly propagates to either
            an interrupt or an alert.";
        } ERR_CODE_TEST[4:0] = 0x0;
    } ERR_CODE_TEST @ 0x40;
    reg {
        field {
            sw = r;
            hw = w;
            desc = "This is the state of the EDN main state machine.
            See the RTL file `edn_main_sm` for the meaning of the values.";
        } MAIN_SM_STATE[8:0] = 0xC1;
    } MAIN_SM_STATE @ 0x44;
};

`endif // _EDN_RDL_DEFINED
