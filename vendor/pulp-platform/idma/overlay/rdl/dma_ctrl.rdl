// SPDX-License-Identifier: Apache-2.0
// SPDX-FileCopyrightText: 2026 Tenstorrent USA, Inc.

`ifndef DMA_CTRL_RDL_DEFINED
`define DMA_CTRL_RDL_DEFINED

addrmap dma_ctrl {
    name = "iDMA Controller Address Map";
    desc = "Source, destination, length, and control registers for the iDMA data-mover engine.";

    reg SRC_ADDRESS_LO {
        field  {
            sw=rw;
            hw=r;
            desc="Source address for DMA to read from, lower 32 bits.";
        } DATA [31:0] = 0x0;
    };

    reg SRC_ADDRESS_HI {
        field  {
            sw=rw;
            hw=r;
            desc="Source address for DMA to read from, upper 32 bits. Bits [31:24] (combined address bits [63:56]) are discarded, not checked; program them as zero.";
        } DATA [31:0] = 0x0;
    };

    reg DST_ADDRESS_LO {
        field  {
            sw=rw;
            hw=r;
            desc="Destination address for DMA to write to, lower 32 bits";
        } DATA [31:0] = 0x0;
    };

    reg DST_ADDRESS_HI {
        field  {
            sw=rw;
            hw=r;
            desc="Destination address for DMA to write to, upper 32 bits. Bits [31:24] (combined address bits [63:56]) are discarded, not checked; program them as zero.";
        } DATA [31:0] = 0x0;
    };

    reg LENGTH_LO {
        field  {
            sw=rw;
            hw=r;
            desc="Number of bytes to move, lower 32 bits.";
        } DATA [31:0] = 0x0;
    };

    reg LENGTH_HI {
        field  {
            sw=rw;
            hw=r;
            desc="Number of bytes to move, upper 32 bits. Bits [31:24] (combined length bits [63:56]) are discarded, not checked; program them as zero.";
        } DATA [31:0] = 0x0;
    };

    reg CONFIG {
        field {
            sw=rw;
            hw=r;
            desc="Write-address decoupling. 0: the write address of each burst is held until the first read data beat of the matching read burst returns. 1: write addresses are issued without waiting for read data.";
        } DECOUPLE_AW[0:0] = 0x0;

        field {
            sw=rw;
            hw=r;
            desc="Read/write decoupling. 0: read and write bursts are formed in lockstep, one write burst per read burst. 1: read and write bursts are formed and issued independently; this mode can deadlock.";
        } DECOUPLE_RW[1:1] = 0x0;

        field {
            sw=rw;
            hw=r;
            desc="Source burst-length reduction. 1: read bursts are limited by SRC_MAX_LLEN. 0: a read burst is at most 256 beats and does not cross a 2 KiB-aligned boundary.";
        } SRC_REDUCE_LEN[2:2] = 0x0;

        field {
            sw=rw;
            hw=r;
            desc="Destination burst-length reduction. 1: write bursts are limited by DST_MAX_LLEN. 0: a write burst is at most 256 beats and does not cross a 2 KiB-aligned boundary.";
        } DST_REDUCE_LEN[3:3] = 0x0;

        field {
            sw=rw;
            hw=r;
            desc="Base-2 logarithm of the maximum read burst length in 64-bit beats, applied when SRC_REDUCE_LEN is 1. A read burst does not cross a boundary aligned to 2^(SRC_MAX_LLEN+3) bytes; 0 gives single-beat bursts. Ignored when SRC_REDUCE_LEN is 0.";
        } SRC_MAX_LLEN[6:4] = 0x0;

        field {
            sw=rw;
            hw=r;
            desc="Base-2 logarithm of the maximum write burst length in 64-bit beats, applied when DST_REDUCE_LEN is 1. A write burst does not cross a boundary aligned to 2^(DST_MAX_LLEN+3) bytes; 0 gives single-beat bursts. Ignored when DST_REDUCE_LEN is 0.";
        } DST_MAX_LLEN[9:7] = 0x0;

        field {
            sw=rw;
            hw=r;
            desc="Repetition enable. 1: the copy is performed NUM_REPETITIONS times, with SRC_STRIDE and DST_STRIDE added to the addresses between rows; set it for every transfer, including a linear copy with NUM_REPETITIONS = 1. 0: the repetition count is forced to zero, so the command completes with an error response, moves no data, and still retires its transfer ID.";
        } ENABLED_ND[10:10] = 0x0;
    };

    reg STATUS {
        field {
            sw=r;
            hw=w;
            desc="Status for the active stream: bits [7:0] each indicate readiness to accept another command, bit 8 indicates midend activity, and bit 9 is zero. These bits do not report backend busy or prove transfer completion; use DONE for completed transfer IDs. Unused streams read zero.";
        } BUSY [9:0] = 0x0;
    };

    reg NEXT_ID {
        field {
            sw=r;
            hw=w;
            desc="Reading this register starts the DMA transfer. Returns an ID value for the cumulative number of transfers. Returns 0 if command was not set up correctly";
        } DATA [31:0] = 0x0;
    };

    reg DONE {
        field {
            sw=r;
            hw=w;
            desc="Holds the cumulative number of completed transfers. Only accumulates when response is seen";
        } DATA [31:0] = 0x0;
    };

    reg SRC_STRIDE_LO {
        field  {
            sw=rw;
            hw=r;
            desc="Stride amount on source address side, lower 32 bits";
        } DATA [31:0] = 0x0;
    };

    reg SRC_STRIDE_HI {
        field  {
            sw=rw;
            hw=r;
            desc="Stride amount on source address side, upper 32 bits. Bits [31:24] (combined stride bits [63:56]) are discarded, not checked; program them as zero.";
        } DATA [31:0] = 0x0;
    };

    reg DST_STRIDE_LO {
        field  {
            sw=rw;
            hw=r;
            desc="Stride amount on destination address side, lower 32 bits";
        } DATA [31:0] = 0x0;
    };

    reg DST_STRIDE_HI {
        field  {
            sw=rw;
            hw=r;
            desc="Stride amount on destination address side, upper 32 bits. Bits [31:24] (combined stride bits [63:56]) are discarded, not checked; program them as zero.";
        } DATA [31:0] = 0x0;
    };

    reg NUM_REPETITIONS_LO {
        field  {
            sw=rw;
            hw=r;
            desc="Number of rows to copy, including the first, lower 32 bits. SRC_STRIDE and DST_STRIDE are added to the addresses between rows. Takes effect only when CONFIG.ENABLED_ND is 1.";
        } DATA [31:0] = 0x0;
    };

    reg NUM_REPETITIONS_HI {
        field  {
            sw=rw;
            hw=r;
            desc="Number of rows to copy, upper 32 bits. The DMA uses only the low 32 bits of the row count, so this register is discarded, not checked; program it as zero.";
        } DATA [31:0] = 0x0;
    };

    ////////////////////////////////////////////////////////////////////////////
    // Address Map
    ////////////////////////////////////////////////////////////////////////////

    CONFIG              CONFIG              @0x0;
    STATUS              STATUS_0            @0x4;
    STATUS              STATUS_1            @0x8;
    STATUS              STATUS_2            @0xc;
    STATUS              STATUS_3            @0x10;
    STATUS              STATUS_4            @0x14;
    STATUS              STATUS_5            @0x18;
    STATUS              STATUS_6            @0x1c;
    STATUS              STATUS_7            @0x20;
    STATUS              STATUS_8            @0x24;
    STATUS              STATUS_9            @0x28;
    STATUS              STATUS_10           @0x2c;
    STATUS              STATUS_11           @0x30;
    STATUS              STATUS_12           @0x34;
    STATUS              STATUS_13           @0x38;
    STATUS              STATUS_14           @0x3c;
    STATUS              STATUS_15           @0x40;
    NEXT_ID             NEXT_ID_0           @0x48;
    NEXT_ID             NEXT_ID_1           @0x50;
    NEXT_ID             NEXT_ID_2           @0x58;
    NEXT_ID             NEXT_ID_3           @0x60;
    NEXT_ID             NEXT_ID_4           @0x68;
    NEXT_ID             NEXT_ID_5           @0x70;
    NEXT_ID             NEXT_ID_6           @0x78;
    NEXT_ID             NEXT_ID_7           @0x80;
    NEXT_ID             NEXT_ID_8           @0x88;
    NEXT_ID             NEXT_ID_9           @0x90;
    NEXT_ID             NEXT_ID_10          @0x98;
    NEXT_ID             NEXT_ID_11          @0xa0;
    NEXT_ID             NEXT_ID_12          @0xa8;
    NEXT_ID             NEXT_ID_13          @0xb0;
    NEXT_ID             NEXT_ID_14          @0xb8;
    NEXT_ID             NEXT_ID_15          @0xc0;
    DONE                DONE_0              @0xC8;
    DONE                DONE_1              ;
    DONE                DONE_2              ;
    DONE                DONE_3              ;
    DONE                DONE_4              ;
    DONE                DONE_5              ;
    DONE                DONE_6              ;
    DONE                DONE_7              ;
    DONE                DONE_8              ;
    DONE                DONE_9              ;
    DONE                DONE_10             ;
    DONE                DONE_11             ;
    DONE                DONE_12             ;
    DONE                DONE_13             ;
    DONE                DONE_14             ;
    DONE                DONE_15             ;
    DST_ADDRESS_LO      DST_ADDRESS_LO      @0x108;
    DST_ADDRESS_HI      DST_ADDRESS_HI      ;
    SRC_ADDRESS_LO      SRC_ADDRESS_LO      ;
    SRC_ADDRESS_HI      SRC_ADDRESS_HI      ;
    LENGTH_LO           LENGTH_LO           ;
    LENGTH_HI           LENGTH_HI           ;
    DST_STRIDE_LO       DST_STRIDE_LO       ;
    DST_STRIDE_HI       DST_STRIDE_HI       ;
    SRC_STRIDE_LO       SRC_STRIDE_LO       ;
    SRC_STRIDE_HI       SRC_STRIDE_HI       ;
    NUM_REPETITIONS_LO  NUM_REPETITIONS_LO  ;
    NUM_REPETITIONS_HI  NUM_REPETITIONS_HI  ;

`ifdef OCAH_DOC_MEMORY_MAP
    ocah_hole_resp = ocah_resp'{rresp: ocah_resp_e::OKAY, rdata: 0xFFFFFFFF, bresp: ocah_resp_e::OKAY};
    ocah_hole_note = "A read fetches the whole 8-byte word, so a read of 0x4C also reads NEXT_ID_0 at 0x48 and launches a transfer.";
`endif
};

`endif